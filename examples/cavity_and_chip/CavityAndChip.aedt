# Ansys Electronics Desktop project, version 2024.2
project variables:
  $TransmonLead_length = 70um
  $JJ_length = 10um
  $TransmonAntena_depth = 665um
  $TransmonAntena_length = 1.8mm
  $ChipBase_width = 1.7mm
  $JJ_width = 4um
  $TransmonAntena_radius = 0.25mm
  $TransmonLead_width = 20um
  $TransmonPad_width = 1000um
  $TransmonAntena_width = 0.1mm
  $TransmonPad_length = 400um
  $ChipBase_length = (28 - 4.75) mm
  $ChipBase_thickness = 0.3mm
  $ChipBase_end = 5.25mm
  $ChipBase_x = -2.905mm
  $ChipBase_y = 19.94mm
  $ChipBase_z = 33.25mm
materials:
  vacuum: permittivity=1
  perfect conductor: conductivity=1e+30
  sapphire: permittivity=10
surface materials:
  Steel-oxidised-surface

design design (HFSS, Eigenmode, model units mm)
variables:
  transmon_wg_radius = 2mm
  sapphire_house_length = 22mm
  spacer = 0.2mm
  sapphire_house_pins_diameter = 0.5mm
  sapphire_house_pins_waveguide_diameter = 1.15mm
  sapphire_house_pins_waveguide_length = 6mm
  pin_1_length = 5.6mm
  pin_2_length = 0mm
  pin_3_length = 6.735mm
  pin_4_length = 0mm
  Lj = 12nH
  ChipBase_x = -1mm
  ChipBase_y = -0.15mm
  ChipBase_z = -22mm - spacer
  ChipBase_length = 22.8mm
  ChipBase_end = ChipBase_length + ChipBase_z
  ChipBase_thickness = 0.3mm
  ChipBase_width = 2mm
  readout_width = 660um
  readout_start_pos_z = - transmon_end + readout_transmon_gap + readout_thickness / 2
  transmon_end = ChipBase_end - 3.015mm
  readout_length = 5.6mm
  readout_transmon_gap = 150um
  readout_fillet = 100um
  readout_start_pos_x = ChipBase_x + ChipBase_width/2
  readout_start_pos_y = ChipBase_y
  readout_thickness = 130um
  purcell_thickness = 130um
  purcell_readout_gap = 2mm
  purcell_start_pos_z = readout_start_pos_z + readout_length + purcell_readout_gap + readout_thickness / 2 + purcell_thickness / 2
  purcell_start_pos_x = ChipBase_x + ChipBase_width/2
  purcell_width = 660um
  purcell_length = 5.76mm
  purcell_fillet = 100um
  purcell_start_pos_y = ChipBase_y
geometry:
  transmon_pin [perfect conductor] = cylinder(axis=Y, base_centre=(0mm, transmon_wg_radius + sapphire_house_pins_waveguide_length, -8mm), radius=sapphire_house_pins_diameter/2, height=-pin_1_length)
  readout_pin [perfect conductor] = cylinder(axis=Y, base_centre=(0mm, -transmon_wg_radius - sapphire_house_pins_waveguide_length, -11mm), radius=sapphire_house_pins_diameter/2, height=pin_2_length)
  pin_3 [perfect conductor] = cylinder(axis=Y, base_centre=(0mm, transmon_wg_radius + sapphire_house_pins_waveguide_length, -15mm), radius=sapphire_house_pins_diameter/2, height=-pin_3_length)
  pin_4 [perfect conductor] = cylinder(axis=Y, base_centre=(0mm, -transmon_wg_radius - sapphire_house_pins_waveguide_length, -18mm), radius=sapphire_house_pins_diameter/2, height=pin_4_length)
  JJ = rectangle(corner=(ChipBase_x + ChipBase_width/2 - $JJ_width/2, ChipBase_y + ChipBase_thickness, ChipBase_end - $TransmonAntena_depth - $TransmonAntena_length - $TransmonLead_length - $JJ_length), z_size=$JJ_length, x_size=$JJ_width)
  line_jj1 = polyline((ChipBase_x + ChipBase_width/2, -ChipBase_y, ChipBase_end - $TransmonAntena_depth - $TransmonAntena_length - $TransmonLead_length - $JJ_length) (ChipBase_x + ChipBase_width/2, -ChipBase_y, ChipBase_end - $TransmonAntena_depth - $TransmonAntena_length - $TransmonLead_length))
  Transmon1 = rectangle(corner=(ChipBase_x + ChipBase_width/2 - $TransmonPad_width/2, ChipBase_y + ChipBase_thickness, ChipBase_end - $TransmonAntena_depth - $TransmonAntena_length), z_size=$TransmonPad_length, x_size=$TransmonPad_width)
  Rectangle15 = rectangle(corner=(ChipBase_x + ChipBase_width/2 - $TransmonAntena_width/2, ChipBase_y + ChipBase_thickness, ChipBase_end - $TransmonAntena_depth - $TransmonAntena_length), z_size=$TransmonAntena_length, x_size=$TransmonAntena_width)
  Circle2 = circle(normal=Y, centre=(ChipBase_x + ChipBase_width/2, ChipBase_y + ChipBase_thickness, ChipBase_end - $TransmonAntena_depth), radius=$TransmonAntena_radius)
  Rectangle16 = rectangle(corner=(ChipBase_x + ChipBase_width/2 - $TransmonLead_width/2, ChipBase_y + ChipBase_thickness, ChipBase_end - $TransmonAntena_depth - $TransmonAntena_length - $TransmonLead_length), z_size=$TransmonLead_length, x_size=$TransmonLead_width)
  Transmon1.unite(Rectangle15, Circle2, Rectangle16)
  Transmon2 = rectangle(corner=(ChipBase_x + ChipBase_width/2 - $TransmonPad_width/2, ChipBase_y + ChipBase_thickness, ChipBase_end - $TransmonAntena_depth - $TransmonAntena_length - $TransmonPad_length - 2 * $TransmonLead_length - $JJ_length), z_size=$TransmonPad_length, x_size=$TransmonPad_width)
  Rectangle17 = rectangle(corner=(ChipBase_x + ChipBase_width/2 - $TransmonLead_width/2, ChipBase_y + ChipBase_thickness, ChipBase_end - $TransmonAntena_depth - $TransmonAntena_length - $TransmonLead_length - $JJ_length - $TransmonLead_length), z_size=$TransmonLead_length, x_size=$TransmonLead_width)
  Transmon2.unite(Rectangle17)
  ChipBase [sapphire] = box(corner=(ChipBase_x, ChipBase_y, ChipBase_z), size=(ChipBase_width, ChipBase_thickness, ChipBase_length))
  jj_meshbox [vacuum, non-model] = box(corner=(ChipBase_x + ChipBase_width/2 - $JJ_width/2 - 0.05mm, ChipBase_y + ChipBase_thickness - 0.05mm, ChipBase_end - $TransmonAntena_depth - $TransmonAntena_length - $TransmonLead_length - $JJ_length - 0.05mm), size=(0.1mm, 0.1mm, 0.1mm))
  trpad_meshbox [vacuum, non-model] = box(corner=(ChipBase_x + ChipBase_width/2 - $JJ_width/2 - 0.75mm, ChipBase_y + ChipBase_thickness - 0.1mm, ChipBase_end - $TransmonAntena_depth - $TransmonAntena_length - $TransmonLead_length - $JJ_length - 0.75mm), size=(1.5mm, 0.2mm, 1.5mm))
  readout_resonator = polyline((readout_start_pos_z, readout_start_pos_x + 0.5*readout_thickness, readout_start_pos_y) (readout_start_pos_z, readout_start_pos_x - 0.5*readout_thickness, readout_start_pos_y))
  cable_0_path1 = polyline(z=readout_start_pos_y, xy: (readout_start_pos_z, readout_start_pos_x) (-17.6*readout_fillet + readout_length/2 + readout_start_pos_z, readout_start_pos_x) (-17.6*readout_fillet + readout_length/2 + readout_start_pos_z, readout_start_pos_x + readout_width) (-15.4*readout_fillet + readout_length/2 + readout_start_pos_z, readout_start_pos_x + readout_width) (-15.4*readout_fillet + readout_length/2 + readout_start_pos_z, readout_start_pos_x - readout_width) (-13.2*readout_fillet + readout_length/2 + readout_start_pos_z, readout_start_pos_x - readout_width) (-13.2*readout_fillet + readout_length/2 + readout_start_pos_z, readout_start_pos_x + readout_width) (-11.0*readout_fillet + readout_length/2 + readout_start_pos_z, readout_start_pos_x + readout_width) (-11.0*readout_fillet + readout_length/2 + readout_start_pos_z, readout_start_pos_x - readout_width) (-8.8*readout_fillet + readout_length/2 + readout_start_pos_z, readout_start_pos_x - readout_width) (-8.8*readout_fillet + readout_length/2 + readout_start_pos_z, readout_start_pos_x + readout_width) (-6.6*readout_fillet + readout_length/2 + readout_start_pos_z, readout_start_pos_x + readout_width) (-6.6*readout_fillet + readout_length/2 + readout_start_pos_z, readout_start_pos_x - readout_width) (-4.4*readout_fillet + readout_length/2 + readout_start_pos_z, readout_start_pos_x - readout_width) (-4.4*readout_fillet + readout_length/2 + readout_start_pos_z, readout_start_pos_x + readout_width) (-2.2*readout_fillet + readout_length/2 + readout_start_pos_z, readout_start_pos_x + readout_width) (-2.2*readout_fillet + readout_length/2 + readout_start_pos_z, readout_start_pos_x - readout_width) (readout_length/2 + readout_start_pos_z, readout_start_pos_x - readout_width) (readout_length/2 + readout_start_pos_z, readout_start_pos_x + readout_width) (2.2*readout_fillet + readout_length/2 + readout_start_pos_z, readout_start_pos_x + readout_width) (2.2*readout_fillet + readout_length/2 + readout_start_pos_z, readout_start_pos_x - readout_width) (4.4*readout_fillet + readout_length/2 + readout_start_pos_z, readout_start_pos_x - readout_width) (4.4*readout_fillet + readout_length/2 + readout_start_pos_z, readout_start_pos_x + readout_width) (6.6*readout_fillet + readout_length/2 + readout_start_pos_z, readout_start_pos_x + readout_width) (6.6*readout_fillet + readout_length/2 + readout_start_pos_z, readout_start_pos_x - readout_width) (8.8*readout_fillet + readout_length/2 + readout_start_pos_z, readout_start_pos_x - readout_width) (8.8*readout_fillet + readout_length/2 + readout_start_pos_z, readout_start_pos_x + readout_width) (11.0*readout_fillet + readout_length/2 + readout_start_pos_z, readout_start_pos_x + readout_width) (11.0*readout_fillet + readout_length/2 + readout_start_pos_z, readout_start_pos_x - readout_width) (13.2*readout_fillet + readout_length/2 + readout_start_pos_z, readout_start_pos_x - readout_width) (13.2*readout_fillet + readout_length/2 + readout_start_pos_z, readout_start_pos_x + readout_width) (15.4*readout_fillet + readout_length/2 + readout_start_pos_z, readout_start_pos_x + readout_width) (15.4*readout_fillet + readout_length/2 + readout_start_pos_z, readout_start_pos_x - readout_width) (17.6*readout_fillet + readout_length/2 + readout_start_pos_z, readout_start_pos_x - readout_width) (17.6*readout_fillet + readout_length/2 + readout_start_pos_z, readout_start_pos_x) (readout_length + readout_start_pos_z, readout_start_pos_x))
  cable_0_path1.fillet(Vertices=cable_0_path1.vertex(at (4.07, 0, -0.15), at (4.07, 0.66, -0.15), at (4.29, 0.66, -0.15), at (4.29, -0.66, -0.15), at (4.51, -0.66, -0.15), at (4.51, 0.66, -0.15), at (4.73, 0.66, -0.15), at (4.73, -0.66, -0.15), at (4.95, -0.66, -0.15), at (4.95, 0.66, -0.15), at (5.17, 0.66, -0.15), at (5.17, -0.66, -0.15)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) Radius=readout_fillet Setback=0mm)
  readout_resonator.sweep_along_path(cable_0_path1)
  readout_resonator.rotate(axis=X, angle=90deg)
  readout_resonator.rotate(axis=Y, angle=90deg)
  Circle5 = circle(normal=Y, centre=(readout_start_pos_x, -readout_start_pos_y, -readout_start_pos_z), radius=purcell_thickness / 2)
  Circle6 = circle(normal=Y, centre=(readout_start_pos_x, -readout_start_pos_y, -readout_start_pos_z - readout_length), radius=purcell_thickness / 2)
  readout_resonator.unite(Circle5, Circle6)
  purcell_resonator = polyline((purcell_start_pos_z, purcell_start_pos_x + 0.5*purcell_thickness, purcell_start_pos_y) (purcell_start_pos_z, purcell_start_pos_x - 0.5*purcell_thickness, purcell_start_pos_y))
  cable_0_path = polyline(z=purcell_start_pos_y, xy: (purcell_start_pos_z, purcell_start_pos_x) (-17.6*purcell_fillet + purcell_length/2 + purcell_start_pos_z, purcell_start_pos_x) (-17.6*purcell_fillet + purcell_length/2 + purcell_start_pos_z, purcell_start_pos_x + purcell_width) (-15.4*purcell_fillet + purcell_length/2 + purcell_start_pos_z, purcell_start_pos_x + purcell_width) (-15.4*purcell_fillet + purcell_length/2 + purcell_start_pos_z, purcell_start_pos_x - purcell_width) (-13.2*purcell_fillet + purcell_length/2 + purcell_start_pos_z, purcell_start_pos_x - purcell_width) (-13.2*purcell_fillet + purcell_length/2 + purcell_start_pos_z, purcell_start_pos_x + purcell_width) (-11.0*purcell_fillet + purcell_length/2 + purcell_start_pos_z, purcell_start_pos_x + purcell_width) (-11.0*purcell_fillet + purcell_length/2 + purcell_start_pos_z, purcell_start_pos_x - purcell_width) (-8.8*purcell_fillet + purcell_length/2 + purcell_start_pos_z, purcell_start_pos_x - purcell_width) (-8.8*purcell_fillet + purcell_length/2 + purcell_start_pos_z, purcell_start_pos_x + purcell_width) (-6.6*purcell_fillet + purcell_length/2 + purcell_start_pos_z, purcell_start_pos_x + purcell_width) (-6.6*purcell_fillet + purcell_length/2 + purcell_start_pos_z, purcell_start_pos_x - purcell_width) (-4.4*purcell_fillet + purcell_length/2 + purcell_start_pos_z, purcell_start_pos_x - purcell_width) (-4.4*purcell_fillet + purcell_length/2 + purcell_start_pos_z, purcell_start_pos_x + purcell_width) (-2.2*purcell_fillet + purcell_length/2 + purcell_start_pos_z, purcell_start_pos_x + purcell_width) (-2.2*purcell_fillet + purcell_length/2 + purcell_start_pos_z, purcell_start_pos_x - purcell_width) (purcell_length/2 + purcell_start_pos_z, purcell_start_pos_x - purcell_width) (purcell_length/2 + purcell_start_pos_z, purcell_start_pos_x + purcell_width) (2.2*purcell_fillet + purcell_length/2 + purcell_start_pos_z, purcell_start_pos_x + purcell_width) (2.2*purcell_fillet + purcell_length/2 + purcell_start_pos_z, purcell_start_pos_x - purcell_width) (4.4*purcell_fillet + purcell_length/2 + purcell_start_pos_z, purcell_start_pos_x - purcell_width) (4.4*purcell_fillet + purcell_length/2 + purcell_start_pos_z, purcell_start_pos_x + purcell_width) (6.6*purcell_fillet + purcell_length/2 + purcell_start_pos_z, purcell_start_pos_x + purcell_width) (6.6*purcell_fillet + purcell_length/2 + purcell_start_pos_z, purcell_start_pos_x - purcell_width) (8.8*purcell_fillet + purcell_length/2 + purcell_start_pos_z, purcell_start_pos_x - purcell_width) (8.8*purcell_fillet + purcell_length/2 + purcell_start_pos_z, purcell_start_pos_x + purcell_width) (11.0*purcell_fillet + purcell_length/2 + purcell_start_pos_z, purcell_start_pos_x + purcell_width) (11.0*purcell_fillet + purcell_length/2 + purcell_start_pos_z, purcell_start_pos_x - purcell_width) (13.2*purcell_fillet + purcell_length/2 + purcell_start_pos_z, purcell_start_pos_x - purcell_width) (13.2*purcell_fillet + purcell_length/2 + purcell_start_pos_z, purcell_start_pos_x + purcell_width) (15.4*purcell_fillet + purcell_length/2 + purcell_start_pos_z, purcell_start_pos_x + purcell_width) (15.4*purcell_fillet + purcell_length/2 + purcell_start_pos_z, purcell_start_pos_x - purcell_width) (17.6*purcell_fillet + purcell_length/2 + purcell_start_pos_z, purcell_start_pos_x - purcell_width) (17.6*purcell_fillet + purcell_length/2 + purcell_start_pos_z, purcell_start_pos_x) (purcell_length + purcell_start_pos_z, purcell_start_pos_x))
  cable_0_path.fillet(Vertices=cable_0_path.vertex(at (11.8625, 0, -0.15), at (11.8625, 0.66, -0.15), at (12.0825, 0.66, -0.15), at (12.0825, -0.66, -0.15), at (12.3025, -0.66, -0.15), at (12.3025, 0.66, -0.15), at (12.5225, 0.66, -0.15), at (12.5225, -0.66, -0.15), at (12.7425, -0.66, -0.15), at (12.7425, 0.66, -0.15), at (12.9625, 0.66, -0.15), at (12.9625, -0.66, -0.15)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) Radius=purcell_fillet Setback=0mm)
  purcell_resonator.sweep_along_path(cable_0_path)
  purcell_resonator.rotate(axis=X, angle=90deg)
  purcell_resonator.rotate(axis=Y, angle=90deg)
  Circle3 = circle(normal=Y, centre=(purcell_start_pos_x, -purcell_start_pos_y, -purcell_start_pos_z), radius=purcell_thickness / 2)
  Circle4 = circle(normal=Y, centre=(purcell_start_pos_x, -purcell_start_pos_y, -purcell_start_pos_z - purcell_length), radius=purcell_thickness / 2)
  purcell_resonator.unite(Circle3, Circle4)
  resonator_meshbox [vacuum, non-model] = box(corner=(ChipBase_x + ChipBase_width/2 - $JJ_width/2 - 0.75mm, ChipBase_y + ChipBase_thickness - 0.1mm, ChipBase_end - $TransmonAntena_depth - $TransmonAntena_length - $TransmonLead_length - $JJ_length - 0.75mm), size=(1.5mm, 0.2mm, -14mm))
  cavity [vacuum] = polyline(x=0mm, yz in mm: (0, 77.260708) (0, -0.5) (2, -0.5) (2.0021411, -0.46729844) (2.0085551, -0.4347369) (2.0192147, -0.40245484) (2.0340742, -0.37059048) (2.0530699, -0.33928027) (2.0761205, -0.30865828) (2.1031273, -0.27885565) (2.1339746, -0.25) (2.1685304, -0.22221488) (2.2066467, -0.19561929) (2.2481602, -0.17032709) (2.2928932, -0.14644661) (2.3406542, -0.1240801) (2.3912386, -0.10332333) (2.4444298, -0.084265194) (2.5, -0.066987298) (2.5577113, -0.051563629) (2.6173166, -0.038060234) (2.6785605, -0.026534935) (2.741181, -0.017037087) (2.8049097, -0.0096073598) (2.8694738, -0.0042775693) (2.9345969, -0.0010705384) (3, 0) (5.1099794, 0) (7.2199588, 0) (9.3299383, 0) (11.439918, 0) (13.549897, 0) (15.659877, 0) (17.769856, 0) (19.879835, 0) (21.989815, 0) (24.099794, 0) (26.209774, 0) (26.534532, 0.013205338) (26.857147, 0.05273416) (27.175487, 0.11832547) (27.487451, 0.2095462) (27.790979, 0.32579403) (28.084067, 0.46630143) (28.364779, 0.63014067) (28.631262, 0.81622998) (28.881758, 1.0233407) (29.114611, 1.2501052) (29.328284, 1.4950265) (29.521367, 1.7564872) (29.692584, 2.0327611) (29.840806, 2.3220241) (29.965053, 2.6223661) (30.064505, 2.9318042) (30.138506, 3.2482953) (30.186567, 3.5697496) (30.20837, 3.8940447) (30.203772, 4.2190394) (30.172803, 4.5425879) (30.115667, 4.8625538) (30.032742, 5.1768246) (29.924575, 5.4833252) (29.786964, 5.817008) (29.641246, 6.1491075) (29.48746, 6.4795333) (29.325648, 6.8081954) (29.155854, 7.1350044) (28.978124, 7.4598714) (28.792506, 7.782708) (28.599052, 8.1034261) (28.397813, 8.4219387) (28.188845, 8.7381589) (27.972204, 9.0520007) (27.74795, 9.3633786) (27.516143, 9.672208) (27.276846, 9.9784047) (27.030125, 10.281885) (26.776047, 10.582568) (26.514681, 10.880369) (26.246098, 11.17521) (25.970371, 11.467008) (25.687575, 11.755685) (25.397787, 12.041163) (25.101087, 12.323363) (24.797554, 12.602209) (24.487272, 12.877625) (24.170324, 13.149535) (23.846798, 13.417867) (23.516781, 13.682546) (23.180363, 13.943502) (22.837636, 14.200661) (22.488693, 14.453956) (22.133628, 14.703317) (21.772539, 14.948675) (21.405524, 15.189965) (21.032682, 15.42712) (20.654116, 15.660076) (20.269928, 15.88877) (19.880223, 16.113139) (19.485107, 16.333122) (19.084687, 16.548659) (18.679072, 16.759693) (18.268373, 16.966164) (17.852702, 17.168017) (17.432172, 17.365198) (17.006897, 17.557652) (16.576992, 17.745327) (16.142576, 17.928172) (15.703766, 18.106137) (15.260682, 18.279174) (14.813444, 18.447236) (14.813433, 18.447239) (14.693477, 18.495101) (14.581213, 18.54742) (14.477304, 18.60389) (14.38236, 18.664177) (14.296941, 18.727926) (14.22155, 18.794763) (14.15663, 18.864293) (14.102565, 18.936108) (14.059672, 19.009784) (14.028203, 19.084887) (14.008345, 19.160976) (14.000214, 19.237603) (14.003858, 19.314315) (14.019255, 19.390662) (14.046315, 19.466193) (14.084879, 19.540465) (14.134719, 19.61304) (14.195542, 19.68349) (14.26699, 19.751401) (14.348642, 19.816373) (14.440018, 19.878023) (14.540578, 19.935989) (14.649732, 19.989928) (14.766837, 20.039524) (14.766846, 20.039528) (15.993798, 20.546977) (17.184906, 21.094316) (18.337501, 21.680318) (19.449001, 22.303671) (20.516913, 22.962976) (21.538845, 23.656757) (22.512507, 24.383459) (23.435717, 25.141453) (24.306405, 25.92904) (25.12262, 26.744455) (25.882534, 27.585872) (26.584442, 28.451404) (27.226773, 29.339111) (27.808086, 30.247004) (28.327078, 31.173049) (28.782588, 32.115169) (29.173593, 33.071255) (29.499217, 34.039162) (29.758731, 35.016722) (29.951554, 36.001745) (30.077252, 36.992022) (30.135545, 37.985334) (30.126301, 38.979455) (30.049542, 39.972158) (29.905439, 40.961217) (29.694316, 41.944416) (29.416645, 42.919551) (29.073049, 43.884438) (28.664298, 44.836913) (28.191307, 45.774843) (27.655138, 46.696124) (27.056991, 47.598694) (26.398206, 48.480528) (25.680262, 49.33965) (24.904765, 50.174136) (24.073455, 50.982115) (23.188194, 51.761776) (22.250967, 52.511372) (21.263873, 53.229223) (20.229125, 53.91372) (19.149042, 54.56333) (18.026044, 55.176596) (16.862649, 55.752144) (15.661462, 56.288684) (14.425177, 56.785014) (13.156564, 57.240022) (11.858466, 57.652687) (10.533792, 58.022085) (9.1855114, 58.347389) (9.1855104, 58.347389) (9.0988511, 58.367969) (9.0142653, 58.390604) (8.9319477, 58.41524) (8.8520877, 58.441822) (8.7748691, 58.470288) (8.7004695, 58.500573) (8.6290601, 58.532607) (8.5608052, 58.566316) (8.495862, 58.601624) (8.4343797, 58.638447) (8.3765, 58.676703) (8.3223559, 58.716302) (8.2720721, 58.757154) (8.2257643, 58.799165) (8.183539, 58.842238) (8.1454934, 58.886273) (8.111715, 58.931171) (8.0822815, 58.976826) (8.0572608, 59.023135) (8.0367103, 59.06999) (8.0206773, 59.117284) (8.0091987, 59.164908) (8.002301, 59.212753) (8, 59.260708) (8, 60.010708) (8, 60.760708) (8, 61.510708) (8, 62.260708) (8, 63.010708) (8, 63.760708) (8, 64.510708) (8, 65.260708) (8, 66.010708) (8, 66.760708) (8, 67.510708) (8, 68.260708) (8, 69.010708) (8, 69.760708) (8, 70.510708) (8, 71.260708) (8, 72.010708) (8, 72.760708) (8, 73.510708) (8, 74.260708) (8, 75.010708) (8, 75.760708) (8, 76.510708) (8, 77.260708) (0, 77.260708), covered, Spline from point 2 over 233)
  cavity.sweep_around_axis(axis=Z, angle=360deg)
  saph_house_back_cylin1 = cylinder(axis=Z, base_centre=(0mm, 2.5mm, -sapphire_house_length), radius=3.5mm, height=-spacer)
  saph_house_back_cylin2 = cylinder(axis=Z, base_centre=(0mm, -2.5mm, -sapphire_house_length), radius=3.5mm, height=-spacer)
  sapphire_house_back = box(corner=(-3.5mm, -2.5mm, -sapphire_house_length), size=(7mm, 5mm, -spacer))
  sapphire_house_wg = cylinder(axis=Z, base_centre=(0mm, 0mm, -sapphire_house_length), radius=transmon_wg_radius, height=sapphire_house_length)
  pin_1_wg = cylinder(axis=Y, base_centre=(0mm, 0mm, -8mm), radius=sapphire_house_pins_waveguide_diameter/2, height=transmon_wg_radius + sapphire_house_pins_waveguide_length)
  pin_2_wg = cylinder(axis=Y, base_centre=(0mm, 0mm, -11mm), radius=sapphire_house_pins_waveguide_diameter/2, height=-transmon_wg_radius - sapphire_house_pins_waveguide_length)
  pin_3_wg = cylinder(axis=Y, base_centre=(0mm, 0mm, -15mm), radius=sapphire_house_pins_waveguide_diameter/2, height=transmon_wg_radius + sapphire_house_pins_waveguide_length)
  pin_4_wg = cylinder(axis=Y, base_centre=(0mm, 0mm, -18mm), radius=sapphire_house_pins_waveguide_diameter/2, height=-transmon_wg_radius - sapphire_house_pins_waveguide_length)
  cavity.unite(saph_house_back_cylin1, saph_house_back_cylin2, sapphire_house_back, sapphire_house_wg, pin_1_wg, pin_2_wg, pin_3_wg, pin_4_wg)
  Polyline2 = polyline((0mm, 0mm, 0mm) (1mm, 0mm, 1mm))
  group Pins = transmon_pin, readout_pin, pin_3, pin_4
  group TransmonChip = JJ, line_jj1, Transmon1, Transmon2, ChipBase
  group Cavity_1 = cavity
boundaries and excitations:
  JJ_inductance: Lumped RLC Objects=JJ CurrentLine{(0, 0.15, -1.935) -> (0, 0.15, -1.945)} RLC_Type=Parallel Inductance=Lj
  PerfectE: Perfect E Objects=[readout_resonator, purcell_resonator, Transmon2, Transmon1]
  readout_pin_impedance: Lumped RLC Faces=cavity.face(at (0, 8, -15)) CurrentLine{(0, 8, -15.25) -> (0, 8, -15.575)} RLC_Type=Parallel Resistance=50ohm
  transmon_pin_impedance: Lumped RLC Faces=cavity.face(at (0, 8, -8)) CurrentLine{(0mm, 8000mm, -8250mm) -> (0, 8, -8.575)} RLC_Type=Parallel Resistance=50ohm
mesh:
  perfect_e_fine_mesh: LengthBased Objects=[Transmon1, Transmon2, purcell_resonator, readout_resonator] MaxLength=50um
  JJ_fine_mesh: LengthBased Objects=JJ MaxLength=1um
  saphire_mesh: LengthBased Objects=ChipBase MaxLength=1mm
  trpad_meshbox: LengthBased RefineInside Objects=trpad_meshbox MaxLength=50um
  jj_meshbox: LengthBased RefineInside Objects=jj_meshbox MaxLength=50um
  resonator_meshbox: LengthBased RefineInside Objects=resonator_meshbox MaxLength=50um
  cavity_mesh: LengthBased RefineInside Objects=cavity MaxLength=4mm
  initial mesh: MeshMethod=AnsoftClassic DynamicSurfaceResolution
setups:
  Setup1: HfssEigen MinimumFrequency=2GHz NumModes=4 MaxDeltaFreq=0.2 ConvergeOnRealFreq=true MaximumPasses=4 MinimumPasses=4 MinimumConvergedPasses=4 PercentRefinement=30 BasisOrder=-1 DoMaterialLambda=false
source amplitudes:
  #-10:1, #-10:2, #-10:4: 0 0deg
  #-10:3: 1 0deg
output variables:
  uri = Mode(4)
field calculator expressions:
  total_magnetic_field = <Hx,Hy,Hz> | Smooth | MaterialOp(Permeability (mu)) | <Hx,Hy,Hz> | Smooth | Conj | Dot | Real | EnterVolume(AllObjects) | VolumeValue | Integrate
  test = <Hx,Hy,Hz> | Smooth | MaterialOp(Permeability (mu)) | <Hx,Hy,Hz> | Smooth | Conj | Dot | Real | EnterVolume(AllObjects) | VolumeValue | Integrate
  test_e = Fundamental_Quantity(0) | Smooth | Fundamental_Quantity(0) | Smooth | Conj | Dot | Real | EnterVolume(AllObjects) | VolumeValue | Integrate
  Jsurf = test | 1/
  total_magnetic_energy = <Hx,Hy,Hz> | MaterialOp(Permeability (mu)) | <Hx,Hy,Hz> | Conj | Dot | Real | EnterVolume(AllObjects) | VolumeValue | Integrate
  total_electric_energy = Fundamental_Quantity(0) | MaterialOp(Permittivity (epsi)) | Fundamental_Quantity(0) | Conj | Dot | Real | EnterVolume(AllObjects) | VolumeValue | Integrate
  current_line_based_e_real = Fundamental_Quantity(0) | Real | Tangent | Dot | EnterLine(line_jj1) | LineValue | Integrate
  current_line_based_e_imag = Fundamental_Quantity(0) | Imag | Tangent | Dot | EnterLine(line_jj1) | LineValue | Integrate
reports:
  Freq. vs. pass: re(Mode(1)), re(Mode(2)), re(Mode(3)), re(Mode(4)), re(Mode(5)), re(Mode(6)) vs Pass on Setup1 : AdaptivePass [$ChipBase_end=5.25mm $ChipBase_thickness=0.3mm $ChipBase_width=1.7mm $ChipBase_x=-2.905mm $ChipBase_y=19.94mm $ChipBase_z=33.25mm $JJ_length=10um $JJ_width=4um $TransmonAntena_depth=665um $TransmonAntena_length=1.8mm $TransmonAntena_radius=0.25mm $TransmonAntena_width=0.1mm $TransmonLead_length=70um $TransmonLead_width=20um $TransmonPad_length=400um $TransmonPad_width=1000um ChipBase_length=24.8mm ChipBase_thickness=0.3mm ChipBase_width=2mm ChipBase_x=-1mm ChipBase_y=-0.15mm Lj=11nH pin_1_length=5.6mm pin_2_length=0mm pin_3_length=6.735mm pin_4_length=0mm purcell_fillet=100um purcell_length=5.765mm purcell_readout_gap=2mm purcell_thickness=130um purcell_width=660um readout_fillet=100um readout_length=5.6mm readout_thickness=130um readout_transmon_gap=150um readout_width=660um sapphire_house_length=22mm sapphire_house_pins_diameter=0.5mm sapphire_house_pins_waveguide_diameter=1.15mm sapphire_house_pins_waveguide_length=6mm spacer=0.001mm transmon_wg_radius=2mm]

design cavity_and_chip (HFSS, Eigenmode, model units mm)
variables:
  transmon_coupler_a = 1mm
  transmon_coupler_b = 0.5mm
  transmon_wg_radius = 2mm
  half_cell_Rc = 31mm
  half_cell_Lc = 21mm
  half_cell_fillet_radius = 4mm
  coupler_a = 2mm
  coupler_b = 1mm
  Iris_radius = 14mm
  full_cell_Rc = 31mm
  full_cell_Lc = 21mm
  cavity_drive_wg_radius = 8mm
  cavity_drive_wg_length = 18mm
  cavity_z_end = 77.474967mm
  cavity_z_midpoint = 19.252233mm
  cavity_drive_pin_diamter = 1mm
  cavity_drive_pin_length = 3mm
  cavity_drive_pin_encloser_diamter = 2.3mm
  cavity_drive_pin_encloser_length = 4mm
  sapphire_house_length = 22mm
  spacer = 0.001mm
  sapphire_house_pins_diameter = 0.5mm
  sapphire_house_pins_waveguide_diameter = 1.15mm
  sapphire_house_pins_waveguide_length = 6mm
  pin_1_length = 6mm
  pin_2_length = 0mm
  pin_3_length = 6.75mm
  pin_4_length = 0mm
  maximum_mesh_size_mm = 2mm
  ChipBase_y = -0.15mm
  ChipBase_x = -1mm
  ChipBase_length = 22.8mm
  ChipBase_end = ChipBase_length + ChipBase_z
  ChipBase_width = 2mm
  ChipBase_z = -22mm - spacer
  ChipBase_thickness = 0.3mm
  Lj = 12nH
geometry:
  cavity [vacuum] = polyline(x=0mm, yz in mm: (0, 77.474967) (0, -0.5) (2, -0.5) (2.0021411, -0.46729844) (2.0085551, -0.4347369) (2.0192147, -0.40245484) (2.0340742, -0.37059048) (2.0530699, -0.33928027) (2.0761205, -0.30865828) (2.1031273, -0.27885565) (2.1339746, -0.25) (2.1685304, -0.22221488) (2.2066467, -0.19561929) (2.2481602, -0.17032709) (2.2928932, -0.14644661) (2.3406542, -0.1240801) (2.3912386, -0.10332333) (2.4444298, -0.084265194) (2.5, -0.066987298) (2.5577113, -0.051563629) (2.6173166, -0.038060234) (2.6785605, -0.026534935) (2.741181, -0.017037087) (2.8049097, -0.0096073598) (2.8694738, -0.0042775693) (2.9345969, -0.0010705384) (3, 0) (5.1099794, 0) (7.2199588, 0) (9.3299383, 0) (11.439918, 0) (13.549897, 0) (15.659877, 0) (17.769856, 0) (19.879835, 0) (21.989815, 0) (24.099794, 0) (26.209774, 0) (26.534532, 0.013205338) (26.857147, 0.05273416) (27.175487, 0.11832547) (27.487451, 0.2095462) (27.790979, 0.32579403) (28.084067, 0.46630143) (28.364779, 0.63014067) (28.631262, 0.81622998) (28.881758, 1.0233407) (29.114611, 1.2501052) (29.328284, 1.4950265) (29.521367, 1.7564872) (29.692584, 2.0327611) (29.840806, 2.3220241) (29.965053, 2.6223661) (30.064505, 2.9318042) (30.138506, 3.2482953) (30.186567, 3.5697496) (30.20837, 3.8940447) (30.203772, 4.2190394) (30.172803, 4.5425879) (30.115667, 4.8625538) (30.032742, 5.1768246) (29.924575, 5.4833252) (29.786964, 5.817008) (29.641246, 6.1491075) (29.48746, 6.4795333) (29.325648, 6.8081954) (29.155854, 7.1350044) (28.978124, 7.4598714) (28.792506, 7.782708) (28.599052, 8.1034261) (28.397813, 8.4219387) (28.188845, 8.7381589) (27.972204, 9.0520007) (27.74795, 9.3633786) (27.516143, 9.672208) (27.276846, 9.9784047) (27.030125, 10.281885) (26.776047, 10.582568) (26.514681, 10.880369) (26.246098, 11.17521) (25.970371, 11.467008) (25.687575, 11.755685) (25.397787, 12.041163) (25.101087, 12.323363) (24.797554, 12.602209) (24.487272, 12.877625) (24.170324, 13.149535) (23.846798, 13.417867) (23.516781, 13.682546) (23.180363, 13.943502) (22.837636, 14.200661) (22.488693, 14.453956) (22.133628, 14.703317) (21.772539, 14.948675) (21.405524, 15.189965) (21.032682, 15.42712) (20.654116, 15.660076) (20.269928, 15.88877) (19.880223, 16.113139) (19.485107, 16.333122) (19.084687, 16.548659) (18.679072, 16.759693) (18.268373, 16.966164) (17.852702, 17.168017) (17.432172, 17.365198) (17.006897, 17.557652) (16.576992, 17.745327) (16.142576, 17.928172) (15.703766, 18.106137) (15.260682, 18.279174) (14.813444, 18.447236) (14.813433, 18.447239) (14.691632, 18.495898) (14.57778, 18.549152) (14.472571, 18.606679) (14.376643, 18.668128) (14.29058, 18.733127) (14.214904, 18.80128) (14.150076, 18.872174) (14.096488, 18.945377) (14.054468, 19.020444) (14.024269, 19.09692) (14.006077, 19.17434) (14, 19.252233) (14.006077, 19.330126) (14.024269, 19.407546) (14.054468, 19.484022) (14.096488, 19.559089) (14.150076, 19.632292) (14.214904, 19.703186) (14.29058, 19.771339) (14.376643, 19.836338) (14.472571, 19.897787) (14.57778, 19.955314) (14.691632, 20.008568) (14.813434, 20.057227) (14.813444, 20.05723) (16.097226, 20.557592) (17.344263, 21.09892) (18.551708, 21.67998) (19.716806, 22.299446) (20.836896, 22.955902) (21.909422, 23.647851) (22.931935, 24.373714) (23.902102, 25.131832) (24.817708, 25.920476) (25.676662, 26.737845) (26.477005, 27.582074) (27.216908, 28.451236) (27.894684, 29.343346) (28.508784, 30.256368) (29.057808, 31.188218) (29.540502, 32.136768) (29.955763, 33.099855) (30.302645, 34.075278) (30.580355, 35.060811) (30.78826, 36.054206) (30.925884, 37.053194) (30.992914, 38.055494) (30.989197, 39.05882) (30.914741, 40.06088) (30.769716, 41.059387) (30.554453, 42.052062) (30.269444, 43.036639) (29.915338, 44.01087) (29.492945, 44.972532) (29.003229, 45.919429) (28.447308, 46.849401) (27.826449, 47.760323) (27.142072, 48.650117) (26.395737, 49.516752) (25.589149, 50.358249) (24.724149, 51.172687) (23.802711, 51.958208) (22.826939, 52.713018) (21.79906, 53.435394) (20.721421, 54.123687) (19.59648, 54.776327) (18.426807, 55.391822) (17.215071, 55.968769) (15.964039, 56.505851) (14.676565, 57.001841) (13.355589, 57.455607) (12.004127, 57.866113) (10.625263, 58.232423) (9.2221443, 58.553699) (9.2221502, 58.553698) (9.1331861, 58.573769) (9.0462863, 58.595986) (8.9616578, 58.620297) (8.8795021, 58.646643) (8.8000148, 58.674961) (8.7233854, 58.705185) (8.6497962, 58.737243) (8.5794225, 58.771057) (8.5124319, 58.806547) (8.448984, 58.843629) (8.3892298, 58.882215) (8.3333117, 58.922212) (8.2813628, 58.963526) (8.2335069, 59.006058) (8.1898578, 59.049707) (8.1505197, 59.094368) (8.115586, 59.139936) (8.0851401, 59.186301) (8.0592545, 59.233354) (8.0379907, 59.280983) (8.0213995, 59.329073) (8.0095203, 59.377511) (8.0023815, 59.426181) (8, 59.474967) (8, 60.224967) (8, 60.974967) (8, 61.724967) (8, 62.474967) (8, 63.224967) (8, 63.974967) (8, 64.724967) (8, 65.474967) (8, 66.224967) (8, 66.974967) (8, 67.724967) (8, 68.474967) (8, 69.224967) (8, 69.974967) (8, 70.724967) (8, 71.474967) (8, 72.224967) (8, 72.974967) (8, 73.724967) (8, 74.474967) (8, 75.224967) (8, 75.974967) (8, 76.724967) (8, 77.474967) (0, 77.474967), covered, Spline from point 2 over 233)
  cavity.sweep_around_axis(axis=Z, angle=360deg)
  saph_house_back_cylin1 = cylinder(axis=Z, base_centre=(0mm, 2.5mm, -sapphire_house_length), radius=3.5mm, height=-spacer)
  saph_house_back_cylin2 = cylinder(axis=Z, base_centre=(0mm, -2.5mm, -sapphire_house_length), radius=3.5mm, height=-spacer)
  sapphire_house_back = box(corner=(-3.5mm, -2.5mm, -sapphire_house_length), size=(7mm, 5mm, -spacer))
  sapphire_house_wg = cylinder(axis=Z, base_centre=(0mm, 0mm, -sapphire_house_length), radius=transmon_wg_radius, height=sapphire_house_length)
  pin_1_wg = cylinder(axis=Y, base_centre=(0mm, 0mm, -8mm), radius=sapphire_house_pins_waveguide_diameter/2, height=transmon_wg_radius + sapphire_house_pins_waveguide_length)
  pin_2_wg = cylinder(axis=Y, base_centre=(0mm, 0mm, -11mm), radius=sapphire_house_pins_waveguide_diameter/2, height=-transmon_wg_radius - sapphire_house_pins_waveguide_length)
  pin_3_wg = cylinder(axis=Y, base_centre=(0mm, 0mm, -15mm), radius=sapphire_house_pins_waveguide_diameter/2, height=transmon_wg_radius + sapphire_house_pins_waveguide_length)
  pin_4_wg = cylinder(axis=Y, base_centre=(0mm, 0mm, -18mm), radius=sapphire_house_pins_waveguide_diameter/2, height=-transmon_wg_radius - sapphire_house_pins_waveguide_length)
  transmon_pin [perfect conductor] = cylinder(axis=Y, base_centre=(0mm, transmon_wg_radius + sapphire_house_pins_waveguide_length, -8mm), radius=sapphire_house_pins_diameter/2, height=-pin_1_length)
  pin_3 [perfect conductor] = cylinder(axis=Y, base_centre=(0mm, transmon_wg_radius + sapphire_house_pins_waveguide_length, -15mm), radius=sapphire_house_pins_diameter/2, height=-pin_3_length)
  pin_1_wg_rlc_bound = object_from(cavity.face(at (0, 8, -8)))
  pin_3_wg_rlc_bound = object_from(cavity.face(at (0, 8, -15)))
  cavity.unite(saph_house_back_cylin1, saph_house_back_cylin2, sapphire_house_back, sapphire_house_wg, pin_1_wg, pin_2_wg, pin_3_wg, pin_4_wg)
  JJ = rectangle(corner=(ChipBase_x + ChipBase_width/2 - $JJ_width/2, ChipBase_y + ChipBase_thickness, ChipBase_end - $TransmonAntena_depth - $TransmonAntena_length - $TransmonLead_length - $JJ_length), z_size=$JJ_length, x_size=$JJ_width)
  line_jj1 = polyline((ChipBase_x + ChipBase_width/2, -ChipBase_y, ChipBase_end - $TransmonAntena_depth - $TransmonAntena_length - $TransmonLead_length - $JJ_length) (ChipBase_x + ChipBase_width/2, -ChipBase_y, ChipBase_end - $TransmonAntena_depth - $TransmonAntena_length - $TransmonLead_length))
  Transmon1 = rectangle(corner=(ChipBase_x + ChipBase_width/2 - $TransmonPad_width/2, ChipBase_y + ChipBase_thickness, ChipBase_end - $TransmonAntena_depth - $TransmonAntena_length), z_size=$TransmonPad_length, x_size=$TransmonPad_width)
  Rectangle15 = rectangle(corner=(ChipBase_x + ChipBase_width/2 - $TransmonAntena_width/2, ChipBase_y + ChipBase_thickness, ChipBase_end - $TransmonAntena_depth - $TransmonAntena_length), z_size=$TransmonAntena_length, x_size=$TransmonAntena_width)
  Circle2 = circle(normal=Y, centre=(ChipBase_x + ChipBase_width/2, ChipBase_y + ChipBase_thickness, ChipBase_end - $TransmonAntena_depth), radius=$TransmonAntena_radius)
  Rectangle16 = rectangle(corner=(ChipBase_x + ChipBase_width/2 - $TransmonLead_width/2, ChipBase_y + ChipBase_thickness, ChipBase_end - $TransmonAntena_depth - $TransmonAntena_length - $TransmonLead_length), z_size=$TransmonLead_length, x_size=$TransmonLead_width)
  Transmon1.unite(Rectangle15, Circle2, Rectangle16)
  Transmon2 = rectangle(corner=(ChipBase_x + ChipBase_width/2 - $TransmonPad_width/2, ChipBase_y + ChipBase_thickness, ChipBase_end - $TransmonAntena_depth - $TransmonAntena_length - $TransmonPad_length - 2 * $TransmonLead_length - $JJ_length), z_size=$TransmonPad_length, x_size=$TransmonPad_width)
  Rectangle17 = rectangle(corner=(ChipBase_x + ChipBase_width/2 - $TransmonLead_width/2, ChipBase_y + ChipBase_thickness, ChipBase_end - $TransmonAntena_depth - $TransmonAntena_length - $TransmonLead_length - $JJ_length - $TransmonLead_length), z_size=$TransmonLead_length, x_size=$TransmonLead_width)
  Transmon2.unite(Rectangle17)
  ChipBase [sapphire] = box(corner=(ChipBase_x, ChipBase_y, ChipBase_z), size=(ChipBase_width, ChipBase_thickness, ChipBase_length))
  jj_meshbox [vacuum, non-model] = box(corner=(ChipBase_x + ChipBase_width/2 - $JJ_width/2 - 0.05mm, ChipBase_y + ChipBase_thickness - 0.05mm, ChipBase_end - $TransmonAntena_depth - $TransmonAntena_length - $TransmonLead_length - $JJ_length - 0.05mm), size=(0.1mm, 0.1mm, 0.1mm))
  trpad_meshbox [vacuum, non-model] = box(corner=(ChipBase_x + ChipBase_width/2 - $JJ_width/2 - 0.75mm, ChipBase_y + ChipBase_thickness - 0.1mm, ChipBase_end - $TransmonAntena_depth - $TransmonAntena_length - $TransmonLead_length - $JJ_length - 0.75mm), size=(1.5mm, 0.2mm, 1.5mm))
  group TransmonChip = JJ, line_jj1, Transmon1, Transmon2, ChipBase
boundaries and excitations:
  Lump_KS4SZI: Lumped RLC Objects=pin_1_wg_rlc_bound CurrentLine{(0, 8, -8) -> (0, 8, -7.425)} RLC_Type=Parallel Resistance=50ohm
  Lump_1XQHVM: Lumped RLC Objects=pin_3_wg_rlc_bound CurrentLine{(0, 8, -15) -> (0, 8, -14.425)} RLC_Type=Parallel Resistance=50ohm
  JJ_inductance: Lumped RLC Objects=JJ CurrentLine{(0, 0.15, -1.736) -> (0, 0.15, -1.746)} RLC_Type=Parallel Inductance=Lj
  PerfE_V5PC1R: Perfect E Objects=[Transmon1, Transmon2]
mesh:
  cavity_mesh: LengthBased RefineInside Objects=cavity NumMaxElem=1000 MaxLength=4mm
  JJ_fine_mesh: LengthBased Objects=JJ MaxLength=1um
  saphire_mesh: LengthBased Objects=ChipBase MaxLength=1mm
  trpad_meshbox: LengthBased RefineInside Objects=trpad_meshbox MaxLength=50um
  jj_meshbox: LengthBased RefineInside Objects=jj_meshbox MaxLength=50um
  perfect_e_mesh: LengthBased Objects=[Transmon1, Transmon2] NumMaxElem=1000 MaxLength=50um
  initial mesh: MeshMethod=AnsoftClassic
setups:
  Setup1: HfssEigen MinimumFrequency=2GHz NumModes=4 MaxDeltaFreq=0.2 ConvergeOnRealFreq=true MaximumPasses=4 MinimumPasses=4 MinimumConvergedPasses=4 PercentRefinement=30 BasisOrder=-1 DoMaterialLambda=false
source amplitudes:
  #-10:1, #-10:2, #-10:4: 0 0deg
  #-10:3: 1 0deg
field calculator expressions:
  total_magnetic_energy = <Hx,Hy,Hz> | MaterialOp(Permeability (mu)) | <Hx,Hy,Hz> | Conj | Dot | Real | EnterVolume(AllObjects) | VolumeValue | Integrate
  total_electric_energy = Fundamental_Quantity(0) | MaterialOp(Permittivity (epsi)) | Fundamental_Quantity(0) | Conj | Dot | Real | EnterVolume(AllObjects) | VolumeValue | Integrate
  current_line_based_e_real = Fundamental_Quantity(0) | Real | Tangent | Dot | EnterLine(line_jj1) | LineValue | Integrate
  current_line_based_e_imag = Fundamental_Quantity(0) | Imag | Tangent | Dot | EnterLine(line_jj1) | LineValue | Integrate
