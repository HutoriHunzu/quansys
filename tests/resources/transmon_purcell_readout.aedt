# Ansys Electronics Desktop project, version 2024.2
materials:
  vacuum: permittivity=1
  perfect conductor: conductivity=1e+30
  silicon: permittivity=11.9
surface materials:
  Steel-oxidised-surface

design my_design (HFSS, Eigenmode, model units mm)
variables:
  spacer_length = -0.1mm
  chip_house_length = 12mm
  chip_house_radius = 2mm
  chip_base_length = 11mm
  chip_base_thickness = 381um
  chip_base_width = 2mm
  pin_waveguide_radius = 0.575mm
  pin_waveguide_length = 6mm
  pin_conductor_radius = 0.25mm
  pin_a_location = 8mm
  pin_b_location = 11mm
  pin_c_location = 15mm
  pin_d_location = 18mm
  pin_a_length = 0mm
  pin_b_length = 0mm
  pin_c_length = 0mm
  pin_d_length = 6.8mm
  purcell_readout_gap = -4mm
  transmon_readout_gap = 0.24mm
  antenna_edge_gap = 0.375mm
  transmon_mesh_box_size_y = 0.4mm
  waveguide_mesh_box_size_y = 0.6mm
  junction_mesh_box_size_scale = 20
  junction_mesh_box_size_y = 0.01mm
  junction_width = 0.001mm
  junction_inductance = 10nH
  transmon_orientation_port_x = 0
  transmon_orientation_port_y = chip_base_thickness / 2
  transmon_orientation_port_z = -chip_house_length - spacer_length + chip_base_length - transmon_size_z - antenna_edge_gap
  transmon_size_x = 1000um
  transmon_size_y = 0um
  transmon_size_z = 2599.998um
  transmon_junction_left_arm_x = transmon_orientation_port_x + 5.798702593962717e-14um
  transmon_junction_left_arm_y = transmon_orientation_port_y + 6.437853132771028e-30um
  transmon_junction_left_arm_z = transmon_orientation_port_z + 473.5um
  transmon_junction_right_arm_x = transmon_orientation_port_x + 5.835441997937139e-14um
  transmon_junction_right_arm_y = transmon_orientation_port_y + 6.478642064974437e-30um
  transmon_junction_right_arm_z = transmon_orientation_port_z + 476.5um
  transmon_antenna_port_x = transmon_orientation_port_x + 1.1634144591899854e-13um
  transmon_antenna_port_y = transmon_orientation_port_y + 1.2916495197745464e-29um
  transmon_antenna_port_z = transmon_orientation_port_z + 950.0um
  transmon_left_narrow_end_x = transmon_orientation_port_x + 5.75583995599256e-14um
  transmon_left_narrow_end_y = transmon_orientation_port_y + 6.390266045200387e-30um
  transmon_left_narrow_end_z = transmon_orientation_port_z + 470.0um
  transmon_right_narrow_end_x = transmon_orientation_port_x + 5.878304635907296e-14um
  transmon_right_narrow_end_y = transmon_orientation_port_y + 6.526229152545078e-30um
  transmon_right_narrow_end_z = transmon_orientation_port_z + 480.0um
  readout_e1_x = 0
  readout_e1_y = chip_base_thickness / 2
  readout_e1_z = transmon_orientation_port_z - transmon_readout_gap
  readout_size_x = 1250um
  readout_size_y = 1.4302972e-14um
  readout_size_z = 8100um
  readout_e2_x = readout_e1_x + 9.91963907309356e-13um
  readout_e2_y = readout_e1_y + 1.1013011694919817e-28um
  readout_e2_z = readout_e1_z + -8100.0um
  purcell_e1_x = readout_e2_x
  purcell_e1_y = readout_e2_y
  purcell_e1_z = readout_e2_z - purcell_readout_gap
  purcell_size_x = 1250um
  purcell_size_y = 1.4302972e-14um
  purcell_size_z = 7300um
  purcell_e2_x = purcell_e1_x + 8.939921633775678e-13um
  purcell_e2_y = purcell_e1_y + 9.925306836162304e-29um
  purcell_e2_z = purcell_e1_z + -7300.0um
  stam_variable = 3mm
  stam_variable_plus_one_mm = stam_variable + 1mm
geometry:
  chip_house_waveguide [vacuum] = cylinder(axis=Z, base_centre=(0mm, 0mm, -chip_house_length), radius=chip_house_radius, height=chip_house_length)
  chip_base [silicon] = box(corner=(-chip_base_width / 2, -chip_base_thickness / 2, -chip_house_length - spacer_length), size=(chip_base_width, chip_base_thickness, chip_base_length))
  transmon_0 = polyline((transmon_orientation_port_x + -500.0um, transmon_orientation_port_y + 0.0um, transmon_orientation_port_z + 98.953um) (transmon_orientation_port_x + -499.956um, transmon_orientation_port_y + 0.0um, transmon_orientation_port_z + 96.859um) (transmon_orientation_port_x + -499.868um, transmon_orientation_port_y + 0.0um, transmon_orientation_port_z + 94.766um) (transmon_orientation_port_x + -499.737um, transmon_orientation_port_y + 0.0um, transmon_orientation_port_z + 92.676um) (transmon_orientation_port_x + -499.562um, transmon_orientation_port_y + 0.0um, transmon_orientation_port_z + 90.589um) (transmon_orientation_port_x + -499.343um, transmon_orientation_port_y + 0.0um, transmon_orientation_port_z + 88.506um) (transmon_orientation_port_x + -499.08um, transmon_orientation_port_y + 0.0um, transmon_orientation_port_z + 86.428um) (transmon_orientation_port_x + -498.774um, transmon_orientation_port_y + 0.0um, transmon_orientation_port_z + 84.356um) (transmon_orientation_port_x + -498.425um, transmon_orientation_port_y + 0.0um, transmon_orientation_port_z + 82.291um) (transmon_orientation_port_x + -498.032um, transmon_orientation_port_y + 0.0um, transmon_orientation_port_z + 80.233um) (transmon_orientation_port_x + -497.597um, transmon_orientation_port_y + 0.0um, transmon_orientation_port_z + 78.184um) (transmon_orientation_port_x + -497.119um, transmon_orientation_port_y + 0.0um, transmon_orientation_port_z + 76.145um) (transmon_orientation_port_x + -496.598um, transmon_orientation_port_y + 0.0um, transmon_orientation_port_z + 74.117um) (transmon_orientation_port_x + -496.035um, transmon_orientation_port_y + 0.0um, transmon_orientation_port_z + 72.099um) (transmon_orientation_port_x + -495.429um, transmon_orientation_port_y + 0.0um, transmon_orientation_port_z + 70.094um) (transmon_orientation_port_x + -494.782um, transmon_orientation_port_y + 0.0um, transmon_orientation_port_z + 68.102um) (transmon_orientation_port_x + -494.093um, transmon_orientation_port_y + 0.0um, transmon_orientation_port_z + 66.124um) (transmon_orientation_port_x + -493.363um, transmon_orientation_port_y + 0.0um, transmon_orientation_port_z + 64.161um) (transmon_orientation_port_x + -492.592um, transmon_orientation_port_y + 0.0um, transmon_orientation_port_z + 62.214um) (transmon_orientation_port_x + -491.78um, transmon_orientation_port_y + 0.0um, transmon_orientation_port_z + 60.283um) (transmon_orientation_port_x + -490.929um, transmon_orientation_port_y + 0.0um, transmon_orientation_port_z + 58.37um) (transmon_orientation_port_x + -490.037um, transmon_orientation_port_y + 0.0um, transmon_orientation_port_z + 56.475um) (transmon_orientation_port_x + -489.106um, transmon_orientation_port_y + 0.0um, transmon_orientation_port_z + 54.598um) (transmon_orientation_port_x + -488.135um, transmon_orientation_port_y + 0.0um, transmon_orientation_port_z + 52.742um) (transmon_orientation_port_x + -487.126um, transmon_orientation_port_y + 0.0um, transmon_orientation_port_z + 50.907um) (transmon_orientation_port_x + -486.079um, transmon_orientation_port_y + 0.0um, transmon_orientation_port_z + 49.093um) (transmon_orientation_port_x + -484.994um, transmon_orientation_port_y + 0.0um, transmon_orientation_port_z + 47.302um) (transmon_orientation_port_x + -483.872um, transmon_orientation_port_y + 0.0um, transmon_orientation_port_z + 45.533um) (transmon_orientation_port_x + -482.713um, transmon_orientation_port_y + 0.0um, transmon_orientation_port_z + 43.789um) (transmon_orientation_port_x + -481.517um, transmon_orientation_port_y + 0.0um, transmon_orientation_port_z + 42.069um) (transmon_orientation_port_x + -480.286um, transmon_orientation_port_y + 0.0um, transmon_orientation_port_z + 40.374um) (transmon_orientation_port_x + -479.02um, transmon_orientation_port_y + 0.0um, transmon_orientation_port_z + 38.706um) (transmon_orientation_port_x + -477.719um, transmon_orientation_port_y + 0.0um, transmon_orientation_port_z + 37.065um) (transmon_orientation_port_x + -476.384um, transmon_orientation_port_y + 0.0um, transmon_orientation_port_z + 35.451um) (transmon_orientation_port_x + -475.015um, transmon_orientation_port_y + 0.0um, transmon_orientation_port_z + 33.865um) (transmon_orientation_port_x + -473.614um, transmon_orientation_port_y + 0.0um, transmon_orientation_port_z + 32.309um) (transmon_orientation_port_x + -472.18um, transmon_orientation_port_y + 0.0um, transmon_orientation_port_z + 30.782um) (transmon_orientation_port_x + -470.715um, transmon_orientation_port_y + 0.0um, transmon_orientation_port_z + 29.285um) (transmon_orientation_port_x + -469.218um, transmon_orientation_port_y + 0.0um, transmon_orientation_port_z + 27.82um) (transmon_orientation_port_x + -467.691um, transmon_orientation_port_y + 0.0um, transmon_orientation_port_z + 26.386um) (transmon_orientation_port_x + -466.135um, transmon_orientation_port_y + 0.0um, transmon_orientation_port_z + 24.985um) (transmon_orientation_port_x + -464.549um, transmon_orientation_port_y + 0.0um, transmon_orientation_port_z + 23.616um) (transmon_orientation_port_x + -462.935um, transmon_orientation_port_y + 0.0um, transmon_orientation_port_z + 22.281um) (transmon_orientation_port_x + -461.294um, transmon_orientation_port_y + 0.0um, transmon_orientation_port_z + 20.98um) (transmon_orientation_port_x + -459.626um, transmon_orientation_port_y + 0.0um, transmon_orientation_port_z + 19.714um) (transmon_orientation_port_x + -457.931um, transmon_orientation_port_y + 0.0um, transmon_orientation_port_z + 18.483um) (transmon_orientation_port_x + -456.211um, transmon_orientation_port_y + 0.0um, transmon_orientation_port_z + 17.287um) (transmon_orientation_port_x + -454.467um, transmon_orientation_port_y + 0.0um, transmon_orientation_port_z + 16.128um) (transmon_orientation_port_x + -452.698um, transmon_orientation_port_y + 0.0um, transmon_orientation_port_z + 15.006um) (transmon_orientation_port_x + -450.907um, transmon_orientation_port_y + 0.0um, transmon_orientation_port_z + 13.921um) (transmon_orientation_port_x + -449.093um, transmon_orientation_port_y + 0.0um, transmon_orientation_port_z + 12.874um) (transmon_orientation_port_x + -447.258um, transmon_orientation_port_y + 0.0um, transmon_orientation_port_z + 11.865um) (transmon_orientation_port_x + -445.402um, transmon_orientation_port_y + 0.0um, transmon_orientation_port_z + 10.894um) (transmon_orientation_port_x + -443.525um, transmon_orientation_port_y + 0.0um, transmon_orientation_port_z + 9.963um) (transmon_orientation_port_x + -441.63um, transmon_orientation_port_y + 0.0um, transmon_orientation_port_z + 9.071um) (transmon_orientation_port_x + -439.717um, transmon_orientation_port_y + 0.0um, transmon_orientation_port_z + 8.22um) (transmon_orientation_port_x + -437.786um, transmon_orientation_port_y + 0.0um, transmon_orientation_port_z + 7.408um) (transmon_orientation_port_x + -435.839um, transmon_orientation_port_y + 0.0um, transmon_orientation_port_z + 6.637um) (transmon_orientation_port_x + -433.876um, transmon_orientation_port_y + 0.0um, transmon_orientation_port_z + 5.907um) (transmon_orientation_port_x + -431.898um, transmon_orientation_port_y + 0.0um, transmon_orientation_port_z + 5.218um) (transmon_orientation_port_x + -429.906um, transmon_orientation_port_y + 0.0um, transmon_orientation_port_z + 4.571um) (transmon_orientation_port_x + -427.901um, transmon_orientation_port_y + 0.0um, transmon_orientation_port_z + 3.965um) (transmon_orientation_port_x + -425.883um, transmon_orientation_port_y + 0.0um, transmon_orientation_port_z + 3.402um) (transmon_orientation_port_x + -423.855um, transmon_orientation_port_y + 0.0um, transmon_orientation_port_z + 2.881um) (transmon_orientation_port_x + -421.816um, transmon_orientation_port_y + 0.0um, transmon_orientation_port_z + 2.403um) (transmon_orientation_port_x + -419.767um, transmon_orientation_port_y + 0.0um, transmon_orientation_port_z + 1.968um) (transmon_orientation_port_x + -417.709um, transmon_orientation_port_y + 0.0um, transmon_orientation_port_z + 1.575um) (transmon_orientation_port_x + -415.644um, transmon_orientation_port_y + 0.0um, transmon_orientation_port_z + 1.226um) (transmon_orientation_port_x + -413.572um, transmon_orientation_port_y + 0.0um, transmon_orientation_port_z + 0.92um) (transmon_orientation_port_x + -411.494um, transmon_orientation_port_y + 0.0um, transmon_orientation_port_z + 0.657um) (transmon_orientation_port_x + -409.411um, transmon_orientation_port_y + 0.0um, transmon_orientation_port_z + 0.438um) (transmon_orientation_port_x + -407.324um, transmon_orientation_port_y + 0.0um, transmon_orientation_port_z + 0.263um) (transmon_orientation_port_x + -405.234um, transmon_orientation_port_y + 0.0um, transmon_orientation_port_z + 0.132um) (transmon_orientation_port_x + -403.141um, transmon_orientation_port_y + 0.0um, transmon_orientation_port_z + 0.044um) (transmon_orientation_port_x + -401.047um, transmon_orientation_port_y + 0.0um, transmon_orientation_port_z + 0.0um) (transmon_orientation_port_x + 401.047um, transmon_orientation_port_y + -0.0um, transmon_orientation_port_z + -0.0um) (transmon_orientation_port_x + 403.141um, transmon_orientation_port_y + -0.0um, transmon_orientation_port_z + 0.044um) (transmon_orientation_port_x + 405.234um, transmon_orientation_port_y + -0.0um, transmon_orientation_port_z + 0.132um) (transmon_orientation_port_x + 407.324um, transmon_orientation_port_y + -0.0um, transmon_orientation_port_z + 0.263um) (transmon_orientation_port_x + 409.411um, transmon_orientation_port_y + -0.0um, transmon_orientation_port_z + 0.438um) (transmon_orientation_port_x + 411.494um, transmon_orientation_port_y + -0.0um, transmon_orientation_port_z + 0.657um) (transmon_orientation_port_x + 413.572um, transmon_orientation_port_y + -0.0um, transmon_orientation_port_z + 0.92um) (transmon_orientation_port_x + 415.644um, transmon_orientation_port_y + -0.0um, transmon_orientation_port_z + 1.226um) (transmon_orientation_port_x + 417.709um, transmon_orientation_port_y + -0.0um, transmon_orientation_port_z + 1.575um) (transmon_orientation_port_x + 419.767um, transmon_orientation_port_y + -0.0um, transmon_orientation_port_z + 1.968um) (transmon_orientation_port_x + 421.816um, transmon_orientation_port_y + -0.0um, transmon_orientation_port_z + 2.403um) (transmon_orientation_port_x + 423.855um, transmon_orientation_port_y + -0.0um, transmon_orientation_port_z + 2.881um) (transmon_orientation_port_x + 425.883um, transmon_orientation_port_y + -0.0um, transmon_orientation_port_z + 3.402um) (transmon_orientation_port_x + 427.901um, transmon_orientation_port_y + -0.0um, transmon_orientation_port_z + 3.965um) (transmon_orientation_port_x + 429.906um, transmon_orientation_port_y + -0.0um, transmon_orientation_port_z + 4.571um) (transmon_orientation_port_x + 431.898um, transmon_orientation_port_y + -0.0um, transmon_orientation_port_z + 5.218um) (transmon_orientation_port_x + 433.876um, transmon_orientation_port_y + -0.0um, transmon_orientation_port_z + 5.907um) (transmon_orientation_port_x + 435.839um, transmon_orientation_port_y + -0.0um, transmon_orientation_port_z + 6.637um) (transmon_orientation_port_x + 437.786um, transmon_orientation_port_y + -0.0um, transmon_orientation_port_z + 7.408um) (transmon_orientation_port_x + 439.717um, transmon_orientation_port_y + -0.0um, transmon_orientation_port_z + 8.22um) (transmon_orientation_port_x + 441.63um, transmon_orientation_port_y + -0.0um, transmon_orientation_port_z + 9.071um) (transmon_orientation_port_x + 443.525um, transmon_orientation_port_y + -0.0um, transmon_orientation_port_z + 9.963um) (transmon_orientation_port_x + 445.402um, transmon_orientation_port_y + -0.0um, transmon_orientation_port_z + 10.894um) (transmon_orientation_port_x + 447.258um, transmon_orientation_port_y + -0.0um, transmon_orientation_port_z + 11.865um) (transmon_orientation_port_x + 449.093um, transmon_orientation_port_y + -0.0um, transmon_orientation_port_z + 12.874um) (transmon_orientation_port_x + 450.907um, transmon_orientation_port_y + -0.0um, transmon_orientation_port_z + 13.921um) (transmon_orientation_port_x + 452.698um, transmon_orientation_port_y + -0.0um, transmon_orientation_port_z + 15.006um) (transmon_orientation_port_x + 454.467um, transmon_orientation_port_y + -0.0um, transmon_orientation_port_z + 16.128um) (transmon_orientation_port_x + 456.211um, transmon_orientation_port_y + -0.0um, transmon_orientation_port_z + 17.287um) (transmon_orientation_port_x + 457.931um, transmon_orientation_port_y + -0.0um, transmon_orientation_port_z + 18.483um) (transmon_orientation_port_x + 459.626um, transmon_orientation_port_y + -0.0um, transmon_orientation_port_z + 19.714um) (transmon_orientation_port_x + 461.294um, transmon_orientation_port_y + -0.0um, transmon_orientation_port_z + 20.98um) (transmon_orientation_port_x + 462.935um, transmon_orientation_port_y + -0.0um, transmon_orientation_port_z + 22.281um) (transmon_orientation_port_x + 464.549um, transmon_orientation_port_y + -0.0um, transmon_orientation_port_z + 23.616um) (transmon_orientation_port_x + 466.135um, transmon_orientation_port_y + -0.0um, transmon_orientation_port_z + 24.985um) (transmon_orientation_port_x + 467.691um, transmon_orientation_port_y + -0.0um, transmon_orientation_port_z + 26.386um) (transmon_orientation_port_x + 469.218um, transmon_orientation_port_y + -0.0um, transmon_orientation_port_z + 27.82um) (transmon_orientation_port_x + 470.715um, transmon_orientation_port_y + -0.0um, transmon_orientation_port_z + 29.285um) (transmon_orientation_port_x + 472.18um, transmon_orientation_port_y + -0.0um, transmon_orientation_port_z + 30.782um) (transmon_orientation_port_x + 473.614um, transmon_orientation_port_y + -0.0um, transmon_orientation_port_z + 32.309um) (transmon_orientation_port_x + 475.015um, transmon_orientation_port_y + -0.0um, transmon_orientation_port_z + 33.865um) (transmon_orientation_port_x + 476.384um, transmon_orientation_port_y + -0.0um, transmon_orientation_port_z + 35.451um) (transmon_orientation_port_x + 477.719um, transmon_orientation_port_y + -0.0um, transmon_orientation_port_z + 37.065um) (transmon_orientation_port_x + 479.02um, transmon_orientation_port_y + -0.0um, transmon_orientation_port_z + 38.706um) (transmon_orientation_port_x + 480.286um, transmon_orientation_port_y + -0.0um, transmon_orientation_port_z + 40.374um) (transmon_orientation_port_x + 481.517um, transmon_orientation_port_y + -0.0um, transmon_orientation_port_z + 42.069um) (transmon_orientation_port_x + 482.713um, transmon_orientation_port_y + -0.0um, transmon_orientation_port_z + 43.789um) (transmon_orientation_port_x + 483.872um, transmon_orientation_port_y + -0.0um, transmon_orientation_port_z + 45.533um) (transmon_orientation_port_x + 484.994um, transmon_orientation_port_y + -0.0um, transmon_orientation_port_z + 47.302um) (transmon_orientation_port_x + 486.079um, transmon_orientation_port_y + -0.0um, transmon_orientation_port_z + 49.093um) (transmon_orientation_port_x + 487.126um, transmon_orientation_port_y + -0.0um, transmon_orientation_port_z + 50.907um) (transmon_orientation_port_x + 488.135um, transmon_orientation_port_y + -0.0um, transmon_orientation_port_z + 52.742um) (transmon_orientation_port_x + 489.106um, transmon_orientation_port_y + -0.0um, transmon_orientation_port_z + 54.598um) (transmon_orientation_port_x + 490.037um, transmon_orientation_port_y + -0.0um, transmon_orientation_port_z + 56.475um) (transmon_orientation_port_x + 490.929um, transmon_orientation_port_y + -0.0um, transmon_orientation_port_z + 58.37um) (transmon_orientation_port_x + 491.78um, transmon_orientation_port_y + -0.0um, transmon_orientation_port_z + 60.283um) (transmon_orientation_port_x + 492.592um, transmon_orientation_port_y + -0.0um, transmon_orientation_port_z + 62.214um) (transmon_orientation_port_x + 493.363um, transmon_orientation_port_y + -0.0um, transmon_orientation_port_z + 64.161um) (transmon_orientation_port_x + 494.093um, transmon_orientation_port_y + -0.0um, transmon_orientation_port_z + 66.124um) (transmon_orientation_port_x + 494.782um, transmon_orientation_port_y + -0.0um, transmon_orientation_port_z + 68.102um) (transmon_orientation_port_x + 495.429um, transmon_orientation_port_y + -0.0um, transmon_orientation_port_z + 70.094um) (transmon_orientation_port_x + 496.035um, transmon_orientation_port_y + -0.0um, transmon_orientation_port_z + 72.099um) (transmon_orientation_port_x + 496.598um, transmon_orientation_port_y + -0.0um, transmon_orientation_port_z + 74.117um) (transmon_orientation_port_x + 497.119um, transmon_orientation_port_y + -0.0um, transmon_orientation_port_z + 76.145um) (transmon_orientation_port_x + 497.597um, transmon_orientation_port_y + -0.0um, transmon_orientation_port_z + 78.184um) (transmon_orientation_port_x + 498.032um, transmon_orientation_port_y + -0.0um, transmon_orientation_port_z + 80.233um) (transmon_orientation_port_x + 498.425um, transmon_orientation_port_y + -0.0um, transmon_orientation_port_z + 82.291um) (transmon_orientation_port_x + 498.774um, transmon_orientation_port_y + -0.0um, transmon_orientation_port_z + 84.356um) (transmon_orientation_port_x + 499.08um, transmon_orientation_port_y + -0.0um, transmon_orientation_port_z + 86.428um) (transmon_orientation_port_x + 499.343um, transmon_orientation_port_y + -0.0um, transmon_orientation_port_z + 88.506um) (transmon_orientation_port_x + 499.562um, transmon_orientation_port_y + -0.0um, transmon_orientation_port_z + 90.589um) (transmon_orientation_port_x + 499.737um, transmon_orientation_port_y + -0.0um, transmon_orientation_port_z + 92.676um) (transmon_orientation_port_x + 499.868um, transmon_orientation_port_y + -0.0um, transmon_orientation_port_z + 94.766um) (transmon_orientation_port_x + 499.956um, transmon_orientation_port_y + -0.0um, transmon_orientation_port_z + 96.859um) (transmon_orientation_port_x + 500.0um, transmon_orientation_port_y + -0.0um, transmon_orientation_port_z + 98.953um) (transmon_orientation_port_x + 500.0um, transmon_orientation_port_y + -0.0um, transmon_orientation_port_z + 301.047um) (transmon_orientation_port_x + 499.956um, transmon_orientation_port_y + -0.0um, transmon_orientation_port_z + 303.141um) (transmon_orientation_port_x + 499.868um, transmon_orientation_port_y + -0.0um, transmon_orientation_port_z + 305.234um) (transmon_orientation_port_x + 499.737um, transmon_orientation_port_y + -0.0um, transmon_orientation_port_z + 307.324um) (transmon_orientation_port_x + 499.562um, transmon_orientation_port_y + -0.0um, transmon_orientation_port_z + 309.411um) (transmon_orientation_port_x + 499.343um, transmon_orientation_port_y + -0.0um, transmon_orientation_port_z + 311.494um) (transmon_orientation_port_x + 499.08um, transmon_orientation_port_y + -0.0um, transmon_orientation_port_z + 313.572um) (transmon_orientation_port_x + 498.774um, transmon_orientation_port_y + -0.0um, transmon_orientation_port_z + 315.644um) (transmon_orientation_port_x + 498.425um, transmon_orientation_port_y + -0.0um, transmon_orientation_port_z + 317.709um) (transmon_orientation_port_x + 498.032um, transmon_orientation_port_y + -0.0um, transmon_orientation_port_z + 319.767um) (transmon_orientation_port_x + 497.597um, transmon_orientation_port_y + -0.0um, transmon_orientation_port_z + 321.816um) (transmon_orientation_port_x + 497.119um, transmon_orientation_port_y + -0.0um, transmon_orientation_port_z + 323.855um) (transmon_orientation_port_x + 496.598um, transmon_orientation_port_y + -0.0um, transmon_orientation_port_z + 325.883um) (transmon_orientation_port_x + 496.035um, transmon_orientation_port_y + -0.0um, transmon_orientation_port_z + 327.901um) (transmon_orientation_port_x + 495.429um, transmon_orientation_port_y + -0.0um, transmon_orientation_port_z + 329.906um) (transmon_orientation_port_x + 494.782um, transmon_orientation_port_y + -0.0um, transmon_orientation_port_z + 331.898um) (transmon_orientation_port_x + 494.093um, transmon_orientation_port_y + -0.0um, transmon_orientation_port_z + 333.876um) (transmon_orientation_port_x + 493.363um, transmon_orientation_port_y + -0.0um, transmon_orientation_port_z + 335.839um) (transmon_orientation_port_x + 492.592um, transmon_orientation_port_y + -0.0um, transmon_orientation_port_z + 337.786um) (transmon_orientation_port_x + 491.78um, transmon_orientation_port_y + -0.0um, transmon_orientation_port_z + 339.717um) (transmon_orientation_port_x + 490.929um, transmon_orientation_port_y + -0.0um, transmon_orientation_port_z + 341.63um) (transmon_orientation_port_x + 490.037um, transmon_orientation_port_y + -0.0um, transmon_orientation_port_z + 343.525um) (transmon_orientation_port_x + 489.106um, transmon_orientation_port_y + -0.0um, transmon_orientation_port_z + 345.402um) (transmon_orientation_port_x + 488.135um, transmon_orientation_port_y + -0.0um, transmon_orientation_port_z + 347.258um) (transmon_orientation_port_x + 487.126um, transmon_orientation_port_y + -0.0um, transmon_orientation_port_z + 349.093um) (transmon_orientation_port_x + 486.079um, transmon_orientation_port_y + -0.0um, transmon_orientation_port_z + 350.907um) (transmon_orientation_port_x + 484.994um, transmon_orientation_port_y + -0.0um, transmon_orientation_port_z + 352.698um) (transmon_orientation_port_x + 483.872um, transmon_orientation_port_y + -0.0um, transmon_orientation_port_z + 354.467um) (transmon_orientation_port_x + 482.713um, transmon_orientation_port_y + -0.0um, transmon_orientation_port_z + 356.211um) (transmon_orientation_port_x + 481.517um, transmon_orientation_port_y + -0.0um, transmon_orientation_port_z + 357.931um) (transmon_orientation_port_x + 480.286um, transmon_orientation_port_y + -0.0um, transmon_orientation_port_z + 359.626um) (transmon_orientation_port_x + 479.02um, transmon_orientation_port_y + -0.0um, transmon_orientation_port_z + 361.294um) (transmon_orientation_port_x + 477.719um, transmon_orientation_port_y + -0.0um, transmon_orientation_port_z + 362.935um) (transmon_orientation_port_x + 476.384um, transmon_orientation_port_y + -0.0um, transmon_orientation_port_z + 364.549um) (transmon_orientation_port_x + 475.015um, transmon_orientation_port_y + -0.0um, transmon_orientation_port_z + 366.135um) (transmon_orientation_port_x + 473.614um, transmon_orientation_port_y + -0.0um, transmon_orientation_port_z + 367.691um) (transmon_orientation_port_x + 472.18um, transmon_orientation_port_y + -0.0um, transmon_orientation_port_z + 369.218um) (transmon_orientation_port_x + 470.715um, transmon_orientation_port_y + -0.0um, transmon_orientation_port_z + 370.715um) (transmon_orientation_port_x + 469.218um, transmon_orientation_port_y + -0.0um, transmon_orientation_port_z + 372.18um) (transmon_orientation_port_x + 467.691um, transmon_orientation_port_y + -0.0um, transmon_orientation_port_z + 373.614um) (transmon_orientation_port_x + 466.135um, transmon_orientation_port_y + -0.0um, transmon_orientation_port_z + 375.015um) (transmon_orientation_port_x + 464.549um, transmon_orientation_port_y + -0.0um, transmon_orientation_port_z + 376.384um) (transmon_orientation_port_x + 462.935um, transmon_orientation_port_y + -0.0um, transmon_orientation_port_z + 377.719um) (transmon_orientation_port_x + 461.294um, transmon_orientation_port_y + -0.0um, transmon_orientation_port_z + 379.02um) (transmon_orientation_port_x + 459.626um, transmon_orientation_port_y + -0.0um, transmon_orientation_port_z + 380.286um) (transmon_orientation_port_x + 457.931um, transmon_orientation_port_y + -0.0um, transmon_orientation_port_z + 381.517um) (transmon_orientation_port_x + 456.211um, transmon_orientation_port_y + -0.0um, transmon_orientation_port_z + 382.713um) (transmon_orientation_port_x + 454.467um, transmon_orientation_port_y + -0.0um, transmon_orientation_port_z + 383.872um) (transmon_orientation_port_x + 452.698um, transmon_orientation_port_y + -0.0um, transmon_orientation_port_z + 384.994um) (transmon_orientation_port_x + 450.907um, transmon_orientation_port_y + -0.0um, transmon_orientation_port_z + 386.079um) (transmon_orientation_port_x + 449.093um, transmon_orientation_port_y + -0.0um, transmon_orientation_port_z + 387.126um) (transmon_orientation_port_x + 447.258um, transmon_orientation_port_y + -0.0um, transmon_orientation_port_z + 388.135um) (transmon_orientation_port_x + 445.402um, transmon_orientation_port_y + -0.0um, transmon_orientation_port_z + 389.106um) (transmon_orientation_port_x + 443.525um, transmon_orientation_port_y + -0.0um, transmon_orientation_port_z + 390.037um) (transmon_orientation_port_x + 441.63um, transmon_orientation_port_y + -0.0um, transmon_orientation_port_z + 390.929um) (transmon_orientation_port_x + 439.717um, transmon_orientation_port_y + -0.0um, transmon_orientation_port_z + 391.78um) (transmon_orientation_port_x + 437.786um, transmon_orientation_port_y + -0.0um, transmon_orientation_port_z + 392.592um) (transmon_orientation_port_x + 435.839um, transmon_orientation_port_y + -0.0um, transmon_orientation_port_z + 393.363um) (transmon_orientation_port_x + 433.876um, transmon_orientation_port_y + -0.0um, transmon_orientation_port_z + 394.093um) (transmon_orientation_port_x + 431.898um, transmon_orientation_port_y + -0.0um, transmon_orientation_port_z + 394.782um) (transmon_orientation_port_x + 429.906um, transmon_orientation_port_y + -0.0um, transmon_orientation_port_z + 395.429um) (transmon_orientation_port_x + 427.901um, transmon_orientation_port_y + -0.0um, transmon_orientation_port_z + 396.035um) (transmon_orientation_port_x + 425.883um, transmon_orientation_port_y + -0.0um, transmon_orientation_port_z + 396.598um) (transmon_orientation_port_x + 423.855um, transmon_orientation_port_y + -0.0um, transmon_orientation_port_z + 397.119um) (transmon_orientation_port_x + 421.816um, transmon_orientation_port_y + -0.0um, transmon_orientation_port_z + 397.597um) (transmon_orientation_port_x + 419.767um, transmon_orientation_port_y + -0.0um, transmon_orientation_port_z + 398.032um) (transmon_orientation_port_x + 417.709um, transmon_orientation_port_y + -0.0um, transmon_orientation_port_z + 398.425um) (transmon_orientation_port_x + 415.644um, transmon_orientation_port_y + -0.0um, transmon_orientation_port_z + 398.774um) (transmon_orientation_port_x + 413.572um, transmon_orientation_port_y + -0.0um, transmon_orientation_port_z + 399.08um) (transmon_orientation_port_x + 411.494um, transmon_orientation_port_y + -0.0um, transmon_orientation_port_z + 399.343um) (transmon_orientation_port_x + 409.411um, transmon_orientation_port_y + -0.0um, transmon_orientation_port_z + 399.562um) (transmon_orientation_port_x + 407.324um, transmon_orientation_port_y + -0.0um, transmon_orientation_port_z + 399.737um) (transmon_orientation_port_x + 405.234um, transmon_orientation_port_y + -0.0um, transmon_orientation_port_z + 399.868um) (transmon_orientation_port_x + 403.141um, transmon_orientation_port_y + -0.0um, transmon_orientation_port_z + 399.956um) (transmon_orientation_port_x + 401.047um, transmon_orientation_port_y + -0.0um, transmon_orientation_port_z + 400.0um) (transmon_orientation_port_x + 29.567um, transmon_orientation_port_y + -0.0um, transmon_orientation_port_z + 400.0um) (transmon_orientation_port_x + 29.356um, transmon_orientation_port_y + -0.0um, transmon_orientation_port_z + 400.004um) (transmon_orientation_port_x + 29.146um, transmon_orientation_port_y + -0.0um, transmon_orientation_port_z + 400.013um) (transmon_orientation_port_x + 28.935um, transmon_orientation_port_y + -0.0um, transmon_orientation_port_z + 400.027um) (transmon_orientation_port_x + 28.725um, transmon_orientation_port_y + -0.0um, transmon_orientation_port_z + 400.044um) (transmon_orientation_port_x + 28.515um, transmon_orientation_port_y + -0.0um, transmon_orientation_port_z + 400.067um) (transmon_orientation_port_x + 28.306um, transmon_orientation_port_y + -0.0um, transmon_orientation_port_z + 400.093um) (transmon_orientation_port_x + 28.097um, transmon_orientation_port_y + -0.0um, transmon_orientation_port_z + 400.124um) (transmon_orientation_port_x + 27.889um, transmon_orientation_port_y + -0.0um, transmon_orientation_port_z + 400.16um) (transmon_orientation_port_x + 27.682um, transmon_orientation_port_y + -0.0um, transmon_orientation_port_z + 400.2um) (transmon_orientation_port_x + 27.476um, transmon_orientation_port_y + -0.0um, transmon_orientation_port_z + 400.244um) (transmon_orientation_port_x + 27.271um, transmon_orientation_port_y + -0.0um, transmon_orientation_port_z + 400.292um) (transmon_orientation_port_x + 27.066um, transmon_orientation_port_y + -0.0um, transmon_orientation_port_z + 400.345um) (transmon_orientation_port_x + 26.863um, transmon_orientation_port_y + -0.0um, transmon_orientation_port_z + 400.402um) (transmon_orientation_port_x + 26.662um, transmon_orientation_port_y + -0.0um, transmon_orientation_port_z + 400.464um) (transmon_orientation_port_x + 26.461um, transmon_orientation_port_y + -0.0um, transmon_orientation_port_z + 400.529um) (transmon_orientation_port_x + 26.262um, transmon_orientation_port_y + -0.0um, transmon_orientation_port_z + 400.599um) (transmon_orientation_port_x + 26.065um, transmon_orientation_port_y + -0.0um, transmon_orientation_port_z + 400.673um) (transmon_orientation_port_x + 25.869um, transmon_orientation_port_y + -0.0um, transmon_orientation_port_z + 400.751um) (transmon_orientation_port_x + 25.674um, transmon_orientation_port_y + -0.0um, transmon_orientation_port_z + 400.833um) (transmon_orientation_port_x + 25.482um, transmon_orientation_port_y + -0.0um, transmon_orientation_port_z + 400.92um) (transmon_orientation_port_x + 25.291um, transmon_orientation_port_y + -0.0um, transmon_orientation_port_z + 401.01um) (transmon_orientation_port_x + 25.103um, transmon_orientation_port_y + -0.0um, transmon_orientation_port_z + 401.105um) (transmon_orientation_port_x + 24.916um, transmon_orientation_port_y + -0.0um, transmon_orientation_port_z + 401.203um) (transmon_orientation_port_x + 24.732um, transmon_orientation_port_y + -0.0um, transmon_orientation_port_z + 401.305um) (transmon_orientation_port_x + 24.549um, transmon_orientation_port_y + -0.0um, transmon_orientation_port_z + 401.411um) (transmon_orientation_port_x + 24.369um, transmon_orientation_port_y + -0.0um, transmon_orientation_port_z + 401.521um) (transmon_orientation_port_x + 24.192um, transmon_orientation_port_y + -0.0um, transmon_orientation_port_z + 401.635um) (transmon_orientation_port_x + 24.017um, transmon_orientation_port_y + -0.0um, transmon_orientation_port_z + 401.753um) (transmon_orientation_port_x + 23.844um, transmon_orientation_port_y + -0.0um, transmon_orientation_port_z + 401.874um) (transmon_orientation_port_x + 23.674um, transmon_orientation_port_y + -0.0um, transmon_orientation_port_z + 401.998um) (transmon_orientation_port_x + 23.506um, transmon_orientation_port_y + -0.0um, transmon_orientation_port_z + 402.127um) (transmon_orientation_port_x + 23.342um, transmon_orientation_port_y + -0.0um, transmon_orientation_port_z + 402.259um) (transmon_orientation_port_x + 23.18um, transmon_orientation_port_y + -0.0um, transmon_orientation_port_z + 402.394um) (transmon_orientation_port_x + 23.021um, transmon_orientation_port_y + -0.0um, transmon_orientation_port_z + 402.532um) (transmon_orientation_port_x + 22.865um, transmon_orientation_port_y + -0.0um, transmon_orientation_port_z + 402.674um) (transmon_orientation_port_x + 22.712um, transmon_orientation_port_y + -0.0um, transmon_orientation_port_z + 402.82um) (transmon_orientation_port_x + 22.562um, transmon_orientation_port_y + -0.0um, transmon_orientation_port_z + 402.968um) (transmon_orientation_port_x + 22.415um, transmon_orientation_port_y + -0.0um, transmon_orientation_port_z + 403.119um) (transmon_orientation_port_x + 22.272um, transmon_orientation_port_y + -0.0um, transmon_orientation_port_z + 403.274um) (transmon_orientation_port_x + 22.132um, transmon_orientation_port_y + -0.0um, transmon_orientation_port_z + 403.432um) (transmon_orientation_port_x + 21.995um, transmon_orientation_port_y + -0.0um, transmon_orientation_port_z + 403.592um) (transmon_orientation_port_x + 21.861um, transmon_orientation_port_y + -0.0um, transmon_orientation_port_z + 403.756um) (transmon_orientation_port_x + 21.731um, transmon_orientation_port_y + -0.0um, transmon_orientation_port_z + 403.922um) (transmon_orientation_port_x + 21.605um, transmon_orientation_port_y + -0.0um, transmon_orientation_port_z + 404.091um) (transmon_orientation_port_x + 21.482um, transmon_orientation_port_y + -0.0um, transmon_orientation_port_z + 404.262um) (transmon_orientation_port_x + 21.363um, transmon_orientation_port_y + -0.0um, transmon_orientation_port_z + 404.436um) (transmon_orientation_port_x + 21.247um, transmon_orientation_port_y + -0.0um, transmon_orientation_port_z + 404.612um) (transmon_orientation_port_x + 21.136um, transmon_orientation_port_y + -0.0um, transmon_orientation_port_z + 404.791um) (transmon_orientation_port_x + 21.028um, transmon_orientation_port_y + -0.0um, transmon_orientation_port_z + 404.973um) (transmon_orientation_port_x + 20.924um, transmon_orientation_port_y + -0.0um, transmon_orientation_port_z + 405.156um) (transmon_orientation_port_x + 20.823um, transmon_orientation_port_y + -0.0um, transmon_orientation_port_z + 405.342um) (transmon_orientation_port_x + 20.727um, transmon_orientation_port_y + -0.0um, transmon_orientation_port_z + 405.529um) (transmon_orientation_port_x + 20.635um, transmon_orientation_port_y + -0.0um, transmon_orientation_port_z + 405.719um) (transmon_orientation_port_x + 20.546um, transmon_orientation_port_y + -0.0um, transmon_orientation_port_z + 405.911um) (transmon_orientation_port_x + 20.462um, transmon_orientation_port_y + -0.0um, transmon_orientation_port_z + 406.104um) (transmon_orientation_port_x + 20.382um, transmon_orientation_port_y + -0.0um, transmon_orientation_port_z + 406.299um) (transmon_orientation_port_x + 20.306um, transmon_orientation_port_y + -0.0um, transmon_orientation_port_z + 406.496um) (transmon_orientation_port_x + 20.234um, transmon_orientation_port_y + -0.0um, transmon_orientation_port_z + 406.694um) (transmon_orientation_port_x + 0.713um, transmon_orientation_port_y + -0.0um, transmon_orientation_port_z + 464.372um) (transmon_orientation_port_x + 0.686um, transmon_orientation_port_y + -0.0um, transmon_orientation_port_z + 464.455um) (transmon_orientation_port_x + 0.662um, transmon_orientation_port_y + -0.0um, transmon_orientation_port_z + 464.539um) (transmon_orientation_port_x + 0.639um, transmon_orientation_port_y + -0.0um, transmon_orientation_port_z + 464.624um) (transmon_orientation_port_x + 0.617um, transmon_orientation_port_y + -0.0um, transmon_orientation_port_z + 464.709um) (transmon_orientation_port_x + 0.598um, transmon_orientation_port_y + -0.0um, transmon_orientation_port_z + 464.794um) (transmon_orientation_port_x + 0.58um, transmon_orientation_port_y + -0.0um, transmon_orientation_port_z + 464.88um) (transmon_orientation_port_x + 0.564um, transmon_orientation_port_y + -0.0um, transmon_orientation_port_z + 464.966um) (transmon_orientation_port_x + 0.55um, transmon_orientation_port_y + -0.0um, transmon_orientation_port_z + 465.053um) (transmon_orientation_port_x + 0.537um, transmon_orientation_port_y + -0.0um, transmon_orientation_port_z + 465.139um) (transmon_orientation_port_x + 0.527um, transmon_orientation_port_y + -0.0um, transmon_orientation_port_z + 465.226um) (transmon_orientation_port_x + 0.518um, transmon_orientation_port_y + -0.0um, transmon_orientation_port_z + 465.313um) (transmon_orientation_port_x + 0.511um, transmon_orientation_port_y + -0.0um, transmon_orientation_port_z + 465.401um) (transmon_orientation_port_x + 0.505um, transmon_orientation_port_y + -0.0um, transmon_orientation_port_z + 465.488um) (transmon_orientation_port_x + 0.502um, transmon_orientation_port_y + -0.0um, transmon_orientation_port_z + 465.575um) (transmon_orientation_port_x + 0.5um, transmon_orientation_port_y + -0.0um, transmon_orientation_port_z + 465.663um)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, closed, covered)
  transmon_1 = polyline((transmon_orientation_port_x + -500.0um, transmon_orientation_port_y + 0.0um, transmon_orientation_port_z + 648.953um) (transmon_orientation_port_x + -499.956um, transmon_orientation_port_y + 0.0um, transmon_orientation_port_z + 646.859um) (transmon_orientation_port_x + -499.868um, transmon_orientation_port_y + 0.0um, transmon_orientation_port_z + 644.766um) (transmon_orientation_port_x + -499.737um, transmon_orientation_port_y + 0.0um, transmon_orientation_port_z + 642.676um) (transmon_orientation_port_x + -499.562um, transmon_orientation_port_y + 0.0um, transmon_orientation_port_z + 640.589um) (transmon_orientation_port_x + -499.343um, transmon_orientation_port_y + 0.0um, transmon_orientation_port_z + 638.506um) (transmon_orientation_port_x + -499.08um, transmon_orientation_port_y + 0.0um, transmon_orientation_port_z + 636.428um) (transmon_orientation_port_x + -498.774um, transmon_orientation_port_y + 0.0um, transmon_orientation_port_z + 634.356um) (transmon_orientation_port_x + -498.425um, transmon_orientation_port_y + 0.0um, transmon_orientation_port_z + 632.291um) (transmon_orientation_port_x + -498.032um, transmon_orientation_port_y + 0.0um, transmon_orientation_port_z + 630.233um) (transmon_orientation_port_x + -497.597um, transmon_orientation_port_y + 0.0um, transmon_orientation_port_z + 628.184um) (transmon_orientation_port_x + -497.119um, transmon_orientation_port_y + 0.0um, transmon_orientation_port_z + 626.145um) (transmon_orientation_port_x + -496.598um, transmon_orientation_port_y + 0.0um, transmon_orientation_port_z + 624.117um) (transmon_orientation_port_x + -496.035um, transmon_orientation_port_y + 0.0um, transmon_orientation_port_z + 622.099um) (transmon_orientation_port_x + -495.429um, transmon_orientation_port_y + 0.0um, transmon_orientation_port_z + 620.094um) (transmon_orientation_port_x + -494.782um, transmon_orientation_port_y + 0.0um, transmon_orientation_port_z + 618.102um) (transmon_orientation_port_x + -494.093um, transmon_orientation_port_y + 0.0um, transmon_orientation_port_z + 616.124um) (transmon_orientation_port_x + -493.363um, transmon_orientation_port_y + 0.0um, transmon_orientation_port_z + 614.161um) (transmon_orientation_port_x + -492.592um, transmon_orientation_port_y + 0.0um, transmon_orientation_port_z + 612.214um) (transmon_orientation_port_x + -491.78um, transmon_orientation_port_y + 0.0um, transmon_orientation_port_z + 610.283um) (transmon_orientation_port_x + -490.929um, transmon_orientation_port_y + 0.0um, transmon_orientation_port_z + 608.37um) (transmon_orientation_port_x + -490.037um, transmon_orientation_port_y + 0.0um, transmon_orientation_port_z + 606.475um) (transmon_orientation_port_x + -489.106um, transmon_orientation_port_y + 0.0um, transmon_orientation_port_z + 604.598um) (transmon_orientation_port_x + -488.135um, transmon_orientation_port_y + 0.0um, transmon_orientation_port_z + 602.742um) (transmon_orientation_port_x + -487.126um, transmon_orientation_port_y + 0.0um, transmon_orientation_port_z + 600.907um) (transmon_orientation_port_x + -486.079um, transmon_orientation_port_y + 0.0um, transmon_orientation_port_z + 599.093um) (transmon_orientation_port_x + -484.994um, transmon_orientation_port_y + 0.0um, transmon_orientation_port_z + 597.302um) (transmon_orientation_port_x + -483.872um, transmon_orientation_port_y + 0.0um, transmon_orientation_port_z + 595.533um) (transmon_orientation_port_x + -482.713um, transmon_orientation_port_y + 0.0um, transmon_orientation_port_z + 593.789um) (transmon_orientation_port_x + -481.517um, transmon_orientation_port_y + 0.0um, transmon_orientation_port_z + 592.069um) (transmon_orientation_port_x + -480.286um, transmon_orientation_port_y + 0.0um, transmon_orientation_port_z + 590.374um) (transmon_orientation_port_x + -479.02um, transmon_orientation_port_y + 0.0um, transmon_orientation_port_z + 588.706um) (transmon_orientation_port_x + -477.719um, transmon_orientation_port_y + 0.0um, transmon_orientation_port_z + 587.065um) (transmon_orientation_port_x + -476.384um, transmon_orientation_port_y + 0.0um, transmon_orientation_port_z + 585.451um) (transmon_orientation_port_x + -475.015um, transmon_orientation_port_y + 0.0um, transmon_orientation_port_z + 583.865um) (transmon_orientation_port_x + -473.614um, transmon_orientation_port_y + 0.0um, transmon_orientation_port_z + 582.309um) (transmon_orientation_port_x + -472.18um, transmon_orientation_port_y + 0.0um, transmon_orientation_port_z + 580.782um) (transmon_orientation_port_x + -470.715um, transmon_orientation_port_y + 0.0um, transmon_orientation_port_z + 579.285um) (transmon_orientation_port_x + -469.218um, transmon_orientation_port_y + 0.0um, transmon_orientation_port_z + 577.82um) (transmon_orientation_port_x + -467.691um, transmon_orientation_port_y + 0.0um, transmon_orientation_port_z + 576.386um) (transmon_orientation_port_x + -466.135um, transmon_orientation_port_y + 0.0um, transmon_orientation_port_z + 574.985um) (transmon_orientation_port_x + -464.549um, transmon_orientation_port_y + 0.0um, transmon_orientation_port_z + 573.616um) (transmon_orientation_port_x + -462.935um, transmon_orientation_port_y + 0.0um, transmon_orientation_port_z + 572.281um) (transmon_orientation_port_x + -461.294um, transmon_orientation_port_y + 0.0um, transmon_orientation_port_z + 570.98um) (transmon_orientation_port_x + -459.626um, transmon_orientation_port_y + 0.0um, transmon_orientation_port_z + 569.714um) (transmon_orientation_port_x + -457.931um, transmon_orientation_port_y + 0.0um, transmon_orientation_port_z + 568.483um) (transmon_orientation_port_x + -456.211um, transmon_orientation_port_y + 0.0um, transmon_orientation_port_z + 567.287um) (transmon_orientation_port_x + -454.467um, transmon_orientation_port_y + 0.0um, transmon_orientation_port_z + 566.128um) (transmon_orientation_port_x + -452.698um, transmon_orientation_port_y + 0.0um, transmon_orientation_port_z + 565.006um) (transmon_orientation_port_x + -450.907um, transmon_orientation_port_y + 0.0um, transmon_orientation_port_z + 563.921um) (transmon_orientation_port_x + -449.093um, transmon_orientation_port_y + 0.0um, transmon_orientation_port_z + 562.874um) (transmon_orientation_port_x + -447.258um, transmon_orientation_port_y + 0.0um, transmon_orientation_port_z + 561.865um) (transmon_orientation_port_x + -445.402um, transmon_orientation_port_y + 0.0um, transmon_orientation_port_z + 560.894um) (transmon_orientation_port_x + -443.525um, transmon_orientation_port_y + 0.0um, transmon_orientation_port_z + 559.963um) (transmon_orientation_port_x + -441.63um, transmon_orientation_port_y + 0.0um, transmon_orientation_port_z + 559.071um) (transmon_orientation_port_x + -439.717um, transmon_orientation_port_y + 0.0um, transmon_orientation_port_z + 558.22um) (transmon_orientation_port_x + -437.786um, transmon_orientation_port_y + 0.0um, transmon_orientation_port_z + 557.408um) (transmon_orientation_port_x + -435.839um, transmon_orientation_port_y + 0.0um, transmon_orientation_port_z + 556.637um) (transmon_orientation_port_x + -433.876um, transmon_orientation_port_y + 0.0um, transmon_orientation_port_z + 555.907um) (transmon_orientation_port_x + -431.898um, transmon_orientation_port_y + 0.0um, transmon_orientation_port_z + 555.218um) (transmon_orientation_port_x + -429.906um, transmon_orientation_port_y + 0.0um, transmon_orientation_port_z + 554.571um) (transmon_orientation_port_x + -427.901um, transmon_orientation_port_y + 0.0um, transmon_orientation_port_z + 553.965um) (transmon_orientation_port_x + -425.883um, transmon_orientation_port_y + 0.0um, transmon_orientation_port_z + 553.402um) (transmon_orientation_port_x + -423.855um, transmon_orientation_port_y + 0.0um, transmon_orientation_port_z + 552.881um) (transmon_orientation_port_x + -421.816um, transmon_orientation_port_y + 0.0um, transmon_orientation_port_z + 552.403um) (transmon_orientation_port_x + -419.767um, transmon_orientation_port_y + 0.0um, transmon_orientation_port_z + 551.968um) (transmon_orientation_port_x + -417.709um, transmon_orientation_port_y + 0.0um, transmon_orientation_port_z + 551.575um) (transmon_orientation_port_x + -415.644um, transmon_orientation_port_y + 0.0um, transmon_orientation_port_z + 551.226um) (transmon_orientation_port_x + -413.572um, transmon_orientation_port_y + 0.0um, transmon_orientation_port_z + 550.92um) (transmon_orientation_port_x + -411.494um, transmon_orientation_port_y + 0.0um, transmon_orientation_port_z + 550.657um) (transmon_orientation_port_x + -409.411um, transmon_orientation_port_y + 0.0um, transmon_orientation_port_z + 550.438um) (transmon_orientation_port_x + -407.324um, transmon_orientation_port_y + 0.0um, transmon_orientation_port_z + 550.263um) (transmon_orientation_port_x + -405.234um, transmon_orientation_port_y + 0.0um, transmon_orientation_port_z + 550.132um) (transmon_orientation_port_x + -403.141um, transmon_orientation_port_y + 0.0um, transmon_orientation_port_z + 550.044um) (transmon_orientation_port_x + -401.047um, transmon_orientation_port_y + 0.0um, transmon_orientation_port_z + 550.0um) (transmon_orientation_port_x + -29.567um, transmon_orientation_port_y + 0.0um, transmon_orientation_port_z + 550.0um) (transmon_orientation_port_x + -29.356um, transmon_orientation_port_y + 0.0um, transmon_orientation_port_z + 549.996um) (transmon_orientation_port_x + -29.146um, transmon_orientation_port_y + 0.0um, transmon_orientation_port_z + 549.987um) (transmon_orientation_port_x + -28.935um, transmon_orientation_port_y + 0.0um, transmon_orientation_port_z + 549.973um) (transmon_orientation_port_x + -28.725um, transmon_orientation_port_y + 0.0um, transmon_orientation_port_z + 549.956um) (transmon_orientation_port_x + -28.515um, transmon_orientation_port_y + 0.0um, transmon_orientation_port_z + 549.933um) (transmon_orientation_port_x + -28.306um, transmon_orientation_port_y + 0.0um, transmon_orientation_port_z + 549.907um) (transmon_orientation_port_x + -28.097um, transmon_orientation_port_y + 0.0um, transmon_orientation_port_z + 549.876um) (transmon_orientation_port_x + -27.889um, transmon_orientation_port_y + 0.0um, transmon_orientation_port_z + 549.84um) (transmon_orientation_port_x + -27.682um, transmon_orientation_port_y + 0.0um, transmon_orientation_port_z + 549.8um) (transmon_orientation_port_x + -27.476um, transmon_orientation_port_y + 0.0um, transmon_orientation_port_z + 549.756um) (transmon_orientation_port_x + -27.271um, transmon_orientation_port_y + 0.0um, transmon_orientation_port_z + 549.708um) (transmon_orientation_port_x + -27.066um, transmon_orientation_port_y + 0.0um, transmon_orientation_port_z + 549.655um) (transmon_orientation_port_x + -26.863um, transmon_orientation_port_y + 0.0um, transmon_orientation_port_z + 549.598um) (transmon_orientation_port_x + -26.662um, transmon_orientation_port_y + 0.0um, transmon_orientation_port_z + 549.536um) (transmon_orientation_port_x + -26.461um, transmon_orientation_port_y + 0.0um, transmon_orientation_port_z + 549.471um) (transmon_orientation_port_x + -26.262um, transmon_orientation_port_y + 0.0um, transmon_orientation_port_z + 549.401um) (transmon_orientation_port_x + -26.065um, transmon_orientation_port_y + 0.0um, transmon_orientation_port_z + 549.327um) (transmon_orientation_port_x + -25.869um, transmon_orientation_port_y + 0.0um, transmon_orientation_port_z + 549.249um) (transmon_orientation_port_x + -25.674um, transmon_orientation_port_y + 0.0um, transmon_orientation_port_z + 549.167um) (transmon_orientation_port_x + -25.482um, transmon_orientation_port_y + 0.0um, transmon_orientation_port_z + 549.08um) (transmon_orientation_port_x + -25.291um, transmon_orientation_port_y + 0.0um, transmon_orientation_port_z + 548.99um) (transmon_orientation_port_x + -25.103um, transmon_orientation_port_y + 0.0um, transmon_orientation_port_z + 548.895um) (transmon_orientation_port_x + -24.916um, transmon_orientation_port_y + 0.0um, transmon_orientation_port_z + 548.797um) (transmon_orientation_port_x + -24.732um, transmon_orientation_port_y + 0.0um, transmon_orientation_port_z + 548.695um) (transmon_orientation_port_x + -24.549um, transmon_orientation_port_y + 0.0um, transmon_orientation_port_z + 548.589um) (transmon_orientation_port_x + -24.369um, transmon_orientation_port_y + 0.0um, transmon_orientation_port_z + 548.479um) (transmon_orientation_port_x + -24.192um, transmon_orientation_port_y + 0.0um, transmon_orientation_port_z + 548.365um) (transmon_orientation_port_x + -24.017um, transmon_orientation_port_y + 0.0um, transmon_orientation_port_z + 548.247um) (transmon_orientation_port_x + -23.844um, transmon_orientation_port_y + 0.0um, transmon_orientation_port_z + 548.126um) (transmon_orientation_port_x + -23.674um, transmon_orientation_port_y + 0.0um, transmon_orientation_port_z + 548.002um) (transmon_orientation_port_x + -23.506um, transmon_orientation_port_y + 0.0um, transmon_orientation_port_z + 547.873um) (transmon_orientation_port_x + -23.342um, transmon_orientation_port_y + 0.0um, transmon_orientation_port_z + 547.741um) (transmon_orientation_port_x + -23.18um, transmon_orientation_port_y + 0.0um, transmon_orientation_port_z + 547.606um) (transmon_orientation_port_x + -23.021um, transmon_orientation_port_y + 0.0um, transmon_orientation_port_z + 547.468um) (transmon_orientation_port_x + -22.865um, transmon_orientation_port_y + 0.0um, transmon_orientation_port_z + 547.326um) (transmon_orientation_port_x + -22.712um, transmon_orientation_port_y + 0.0um, transmon_orientation_port_z + 547.18um) (transmon_orientation_port_x + -22.562um, transmon_orientation_port_y + 0.0um, transmon_orientation_port_z + 547.032um) (transmon_orientation_port_x + -22.415um, transmon_orientation_port_y + 0.0um, transmon_orientation_port_z + 546.881um) (transmon_orientation_port_x + -22.272um, transmon_orientation_port_y + 0.0um, transmon_orientation_port_z + 546.726um) (transmon_orientation_port_x + -22.132um, transmon_orientation_port_y + 0.0um, transmon_orientation_port_z + 546.568um) (transmon_orientation_port_x + -21.995um, transmon_orientation_port_y + 0.0um, transmon_orientation_port_z + 546.408um) (transmon_orientation_port_x + -21.861um, transmon_orientation_port_y + 0.0um, transmon_orientation_port_z + 546.244um) (transmon_orientation_port_x + -21.731um, transmon_orientation_port_y + 0.0um, transmon_orientation_port_z + 546.078um) (transmon_orientation_port_x + -21.605um, transmon_orientation_port_y + 0.0um, transmon_orientation_port_z + 545.909um) (transmon_orientation_port_x + -21.482um, transmon_orientation_port_y + 0.0um, transmon_orientation_port_z + 545.738um) (transmon_orientation_port_x + -21.363um, transmon_orientation_port_y + 0.0um, transmon_orientation_port_z + 545.564um) (transmon_orientation_port_x + -21.247um, transmon_orientation_port_y + 0.0um, transmon_orientation_port_z + 545.388um) (transmon_orientation_port_x + -21.136um, transmon_orientation_port_y + 0.0um, transmon_orientation_port_z + 545.209um) (transmon_orientation_port_x + -21.028um, transmon_orientation_port_y + 0.0um, transmon_orientation_port_z + 545.027um) (transmon_orientation_port_x + -20.924um, transmon_orientation_port_y + 0.0um, transmon_orientation_port_z + 544.844um) (transmon_orientation_port_x + -20.823um, transmon_orientation_port_y + 0.0um, transmon_orientation_port_z + 544.658um) (transmon_orientation_port_x + -20.727um, transmon_orientation_port_y + 0.0um, transmon_orientation_port_z + 544.471um) (transmon_orientation_port_x + -20.635um, transmon_orientation_port_y + 0.0um, transmon_orientation_port_z + 544.281um) (transmon_orientation_port_x + -20.546um, transmon_orientation_port_y + 0.0um, transmon_orientation_port_z + 544.089um) (transmon_orientation_port_x + -20.462um, transmon_orientation_port_y + 0.0um, transmon_orientation_port_z + 543.896um) (transmon_orientation_port_x + -20.382um, transmon_orientation_port_y + 0.0um, transmon_orientation_port_z + 543.701um) (transmon_orientation_port_x + -20.306um, transmon_orientation_port_y + 0.0um, transmon_orientation_port_z + 543.504um) (transmon_orientation_port_x + -20.234um, transmon_orientation_port_y + 0.0um, transmon_orientation_port_z + 543.306um) (transmon_orientation_port_x + -0.713um, transmon_orientation_port_y + 0.0um, transmon_orientation_port_z + 485.628um) (transmon_orientation_port_x + -0.686um, transmon_orientation_port_y + 0.0um, transmon_orientation_port_z + 485.545um) (transmon_orientation_port_x + -0.662um, transmon_orientation_port_y + 0.0um, transmon_orientation_port_z + 485.461um) (transmon_orientation_port_x + -0.639um, transmon_orientation_port_y + 0.0um, transmon_orientation_port_z + 485.376um) (transmon_orientation_port_x + -0.617um, transmon_orientation_port_y + 0.0um, transmon_orientation_port_z + 485.291um) (transmon_orientation_port_x + -0.598um, transmon_orientation_port_y + 0.0um, transmon_orientation_port_z + 485.206um) (transmon_orientation_port_x + -0.58um, transmon_orientation_port_y + 0.0um, transmon_orientation_port_z + 485.12um) (transmon_orientation_port_x + -0.564um, transmon_orientation_port_y + 0.0um, transmon_orientation_port_z + 485.034um) (transmon_orientation_port_x + -0.55um, transmon_orientation_port_y + 0.0um, transmon_orientation_port_z + 484.947um) (transmon_orientation_port_x + -0.537um, transmon_orientation_port_y + 0.0um, transmon_orientation_port_z + 484.861um) (transmon_orientation_port_x + -0.527um, transmon_orientation_port_y + 0.0um, transmon_orientation_port_z + 484.774um) (transmon_orientation_port_x + -0.518um, transmon_orientation_port_y + 0.0um, transmon_orientation_port_z + 484.687um) (transmon_orientation_port_x + -0.511um, transmon_orientation_port_y + 0.0um, transmon_orientation_port_z + 484.599um) (transmon_orientation_port_x + -0.505um, transmon_orientation_port_y + 0.0um, transmon_orientation_port_z + 484.512um) (transmon_orientation_port_x + -0.502um, transmon_orientation_port_y + 0.0um, transmon_orientation_port_z + 484.425um) (transmon_orientation_port_x + -0.5um, transmon_orientation_port_y + 0.0um, transmon_orientation_port_z + 484.337um) (transmon_orientation_port_x + -0.5um, transmon_orientation_port_y + 0.0um, transmon_orientation_port_z + 476.5um) (transmon_orientation_port_x + 0.5um, transmon_orientation_port_y + -0.0um, transmon_orientation_port_z + 476.5um) (transmon_orientation_port_x + 0.5um, transmon_orientation_port_y + -0.0um, transmon_orientation_port_z + 484.337um) (transmon_orientation_port_x + 0.502um, transmon_orientation_port_y + -0.0um, transmon_orientation_port_z + 484.425um) (transmon_orientation_port_x + 0.505um, transmon_orientation_port_y + -0.0um, transmon_orientation_port_z + 484.512um) (transmon_orientation_port_x + 0.511um, transmon_orientation_port_y + -0.0um, transmon_orientation_port_z + 484.599um) (transmon_orientation_port_x + 0.518um, transmon_orientation_port_y + -0.0um, transmon_orientation_port_z + 484.687um) (transmon_orientation_port_x + 0.527um, transmon_orientation_port_y + -0.0um, transmon_orientation_port_z + 484.774um) (transmon_orientation_port_x + 0.537um, transmon_orientation_port_y + -0.0um, transmon_orientation_port_z + 484.861um) (transmon_orientation_port_x + 0.55um, transmon_orientation_port_y + -0.0um, transmon_orientation_port_z + 484.947um) (transmon_orientation_port_x + 0.564um, transmon_orientation_port_y + -0.0um, transmon_orientation_port_z + 485.034um) (transmon_orientation_port_x + 0.58um, transmon_orientation_port_y + -0.0um, transmon_orientation_port_z + 485.12um) (transmon_orientation_port_x + 0.598um, transmon_orientation_port_y + -0.0um, transmon_orientation_port_z + 485.206um) (transmon_orientation_port_x + 0.617um, transmon_orientation_port_y + -0.0um, transmon_orientation_port_z + 485.291um) (transmon_orientation_port_x + 0.639um, transmon_orientation_port_y + -0.0um, transmon_orientation_port_z + 485.376um) (transmon_orientation_port_x + 0.662um, transmon_orientation_port_y + -0.0um, transmon_orientation_port_z + 485.461um) (transmon_orientation_port_x + 0.686um, transmon_orientation_port_y + -0.0um, transmon_orientation_port_z + 485.545um) (transmon_orientation_port_x + 0.713um, transmon_orientation_port_y + -0.0um, transmon_orientation_port_z + 485.628um) (transmon_orientation_port_x + 20.234um, transmon_orientation_port_y + -0.0um, transmon_orientation_port_z + 543.306um) (transmon_orientation_port_x + 20.306um, transmon_orientation_port_y + -0.0um, transmon_orientation_port_z + 543.504um) (transmon_orientation_port_x + 20.382um, transmon_orientation_port_y + -0.0um, transmon_orientation_port_z + 543.701um) (transmon_orientation_port_x + 20.462um, transmon_orientation_port_y + -0.0um, transmon_orientation_port_z + 543.896um) (transmon_orientation_port_x + 20.546um, transmon_orientation_port_y + -0.0um, transmon_orientation_port_z + 544.089um) (transmon_orientation_port_x + 20.635um, transmon_orientation_port_y + -0.0um, transmon_orientation_port_z + 544.281um) (transmon_orientation_port_x + 20.727um, transmon_orientation_port_y + -0.0um, transmon_orientation_port_z + 544.471um) (transmon_orientation_port_x + 20.823um, transmon_orientation_port_y + -0.0um, transmon_orientation_port_z + 544.658um) (transmon_orientation_port_x + 20.924um, transmon_orientation_port_y + -0.0um, transmon_orientation_port_z + 544.844um) (transmon_orientation_port_x + 21.028um, transmon_orientation_port_y + -0.0um, transmon_orientation_port_z + 545.027um) (transmon_orientation_port_x + 21.136um, transmon_orientation_port_y + -0.0um, transmon_orientation_port_z + 545.209um) (transmon_orientation_port_x + 21.247um, transmon_orientation_port_y + -0.0um, transmon_orientation_port_z + 545.388um) (transmon_orientation_port_x + 21.363um, transmon_orientation_port_y + -0.0um, transmon_orientation_port_z + 545.564um) (transmon_orientation_port_x + 21.482um, transmon_orientation_port_y + -0.0um, transmon_orientation_port_z + 545.738um) (transmon_orientation_port_x + 21.605um, transmon_orientation_port_y + -0.0um, transmon_orientation_port_z + 545.909um) (transmon_orientation_port_x + 21.731um, transmon_orientation_port_y + -0.0um, transmon_orientation_port_z + 546.078um) (transmon_orientation_port_x + 21.861um, transmon_orientation_port_y + -0.0um, transmon_orientation_port_z + 546.244um) (transmon_orientation_port_x + 21.995um, transmon_orientation_port_y + -0.0um, transmon_orientation_port_z + 546.408um) (transmon_orientation_port_x + 22.132um, transmon_orientation_port_y + -0.0um, transmon_orientation_port_z + 546.568um) (transmon_orientation_port_x + 22.272um, transmon_orientation_port_y + -0.0um, transmon_orientation_port_z + 546.726um) (transmon_orientation_port_x + 22.415um, transmon_orientation_port_y + -0.0um, transmon_orientation_port_z + 546.881um) (transmon_orientation_port_x + 22.562um, transmon_orientation_port_y + -0.0um, transmon_orientation_port_z + 547.032um) (transmon_orientation_port_x + 22.712um, transmon_orientation_port_y + -0.0um, transmon_orientation_port_z + 547.18um) (transmon_orientation_port_x + 22.865um, transmon_orientation_port_y + -0.0um, transmon_orientation_port_z + 547.326um) (transmon_orientation_port_x + 23.021um, transmon_orientation_port_y + -0.0um, transmon_orientation_port_z + 547.468um) (transmon_orientation_port_x + 23.18um, transmon_orientation_port_y + -0.0um, transmon_orientation_port_z + 547.606um) (transmon_orientation_port_x + 23.342um, transmon_orientation_port_y + -0.0um, transmon_orientation_port_z + 547.741um) (transmon_orientation_port_x + 23.506um, transmon_orientation_port_y + -0.0um, transmon_orientation_port_z + 547.873um) (transmon_orientation_port_x + 23.674um, transmon_orientation_port_y + -0.0um, transmon_orientation_port_z + 548.002um) (transmon_orientation_port_x + 23.844um, transmon_orientation_port_y + -0.0um, transmon_orientation_port_z + 548.126um) (transmon_orientation_port_x + 24.017um, transmon_orientation_port_y + -0.0um, transmon_orientation_port_z + 548.247um) (transmon_orientation_port_x + 24.192um, transmon_orientation_port_y + -0.0um, transmon_orientation_port_z + 548.365um) (transmon_orientation_port_x + 24.369um, transmon_orientation_port_y + -0.0um, transmon_orientation_port_z + 548.479um) (transmon_orientation_port_x + 24.549um, transmon_orientation_port_y + -0.0um, transmon_orientation_port_z + 548.589um) (transmon_orientation_port_x + 24.732um, transmon_orientation_port_y + -0.0um, transmon_orientation_port_z + 548.695um) (transmon_orientation_port_x + 24.916um, transmon_orientation_port_y + -0.0um, transmon_orientation_port_z + 548.797um) (transmon_orientation_port_x + 25.103um, transmon_orientation_port_y + -0.0um, transmon_orientation_port_z + 548.895um) (transmon_orientation_port_x + 25.291um, transmon_orientation_port_y + -0.0um, transmon_orientation_port_z + 548.99um) (transmon_orientation_port_x + 25.482um, transmon_orientation_port_y + -0.0um, transmon_orientation_port_z + 549.08um) (transmon_orientation_port_x + 25.674um, transmon_orientation_port_y + -0.0um, transmon_orientation_port_z + 549.167um) (transmon_orientation_port_x + 25.869um, transmon_orientation_port_y + -0.0um, transmon_orientation_port_z + 549.249um) (transmon_orientation_port_x + 26.065um, transmon_orientation_port_y + -0.0um, transmon_orientation_port_z + 549.327um) (transmon_orientation_port_x + 26.262um, transmon_orientation_port_y + -0.0um, transmon_orientation_port_z + 549.401um) (transmon_orientation_port_x + 26.461um, transmon_orientation_port_y + -0.0um, transmon_orientation_port_z + 549.471um) (transmon_orientation_port_x + 26.662um, transmon_orientation_port_y + -0.0um, transmon_orientation_port_z + 549.536um) (transmon_orientation_port_x + 26.863um, transmon_orientation_port_y + -0.0um, transmon_orientation_port_z + 549.598um) (transmon_orientation_port_x + 27.066um, transmon_orientation_port_y + -0.0um, transmon_orientation_port_z + 549.655um) (transmon_orientation_port_x + 27.271um, transmon_orientation_port_y + -0.0um, transmon_orientation_port_z + 549.708um) (transmon_orientation_port_x + 27.476um, transmon_orientation_port_y + -0.0um, transmon_orientation_port_z + 549.756um) (transmon_orientation_port_x + 27.682um, transmon_orientation_port_y + -0.0um, transmon_orientation_port_z + 549.8um) (transmon_orientation_port_x + 27.889um, transmon_orientation_port_y + -0.0um, transmon_orientation_port_z + 549.84um) (transmon_orientation_port_x + 28.097um, transmon_orientation_port_y + -0.0um, transmon_orientation_port_z + 549.876um) (transmon_orientation_port_x + 28.306um, transmon_orientation_port_y + -0.0um, transmon_orientation_port_z + 549.907um) (transmon_orientation_port_x + 28.515um, transmon_orientation_port_y + -0.0um, transmon_orientation_port_z + 549.933um) (transmon_orientation_port_x + 28.725um, transmon_orientation_port_y + -0.0um, transmon_orientation_port_z + 549.956um) (transmon_orientation_port_x + 28.935um, transmon_orientation_port_y + -0.0um, transmon_orientation_port_z + 549.973um) (transmon_orientation_port_x + 29.146um, transmon_orientation_port_y + -0.0um, transmon_orientation_port_z + 549.987um) (transmon_orientation_port_x + 29.356um, transmon_orientation_port_y + -0.0um, transmon_orientation_port_z + 549.996um) (transmon_orientation_port_x + 29.567um, transmon_orientation_port_y + -0.0um, transmon_orientation_port_z + 550.0um) (transmon_orientation_port_x + 401.047um, transmon_orientation_port_y + -0.0um, transmon_orientation_port_z + 550.0um) (transmon_orientation_port_x + 403.141um, transmon_orientation_port_y + -0.0um, transmon_orientation_port_z + 550.044um) (transmon_orientation_port_x + 405.234um, transmon_orientation_port_y + -0.0um, transmon_orientation_port_z + 550.132um) (transmon_orientation_port_x + 407.324um, transmon_orientation_port_y + -0.0um, transmon_orientation_port_z + 550.263um) (transmon_orientation_port_x + 409.411um, transmon_orientation_port_y + -0.0um, transmon_orientation_port_z + 550.438um) (transmon_orientation_port_x + 411.494um, transmon_orientation_port_y + -0.0um, transmon_orientation_port_z + 550.657um) (transmon_orientation_port_x + 413.572um, transmon_orientation_port_y + -0.0um, transmon_orientation_port_z + 550.92um) (transmon_orientation_port_x + 415.644um, transmon_orientation_port_y + -0.0um, transmon_orientation_port_z + 551.226um) (transmon_orientation_port_x + 417.709um, transmon_orientation_port_y + -0.0um, transmon_orientation_port_z + 551.575um) (transmon_orientation_port_x + 419.767um, transmon_orientation_port_y + -0.0um, transmon_orientation_port_z + 551.968um) (transmon_orientation_port_x + 421.816um, transmon_orientation_port_y + -0.0um, transmon_orientation_port_z + 552.403um) (transmon_orientation_port_x + 423.855um, transmon_orientation_port_y + -0.0um, transmon_orientation_port_z + 552.881um) (transmon_orientation_port_x + 425.883um, transmon_orientation_port_y + -0.0um, transmon_orientation_port_z + 553.402um) (transmon_orientation_port_x + 427.901um, transmon_orientation_port_y + -0.0um, transmon_orientation_port_z + 553.965um) (transmon_orientation_port_x + 429.906um, transmon_orientation_port_y + -0.0um, transmon_orientation_port_z + 554.571um) (transmon_orientation_port_x + 431.898um, transmon_orientation_port_y + -0.0um, transmon_orientation_port_z + 555.218um) (transmon_orientation_port_x + 433.876um, transmon_orientation_port_y + -0.0um, transmon_orientation_port_z + 555.907um) (transmon_orientation_port_x + 435.839um, transmon_orientation_port_y + -0.0um, transmon_orientation_port_z + 556.637um) (transmon_orientation_port_x + 437.786um, transmon_orientation_port_y + -0.0um, transmon_orientation_port_z + 557.408um) (transmon_orientation_port_x + 439.717um, transmon_orientation_port_y + -0.0um, transmon_orientation_port_z + 558.22um) (transmon_orientation_port_x + 441.63um, transmon_orientation_port_y + -0.0um, transmon_orientation_port_z + 559.071um) (transmon_orientation_port_x + 443.525um, transmon_orientation_port_y + -0.0um, transmon_orientation_port_z + 559.963um) (transmon_orientation_port_x + 445.402um, transmon_orientation_port_y + -0.0um, transmon_orientation_port_z + 560.894um) (transmon_orientation_port_x + 447.258um, transmon_orientation_port_y + -0.0um, transmon_orientation_port_z + 561.865um) (transmon_orientation_port_x + 449.093um, transmon_orientation_port_y + -0.0um, transmon_orientation_port_z + 562.874um) (transmon_orientation_port_x + 450.907um, transmon_orientation_port_y + -0.0um, transmon_orientation_port_z + 563.921um) (transmon_orientation_port_x + 452.698um, transmon_orientation_port_y + -0.0um, transmon_orientation_port_z + 565.006um) (transmon_orientation_port_x + 454.467um, transmon_orientation_port_y + -0.0um, transmon_orientation_port_z + 566.128um) (transmon_orientation_port_x + 456.211um, transmon_orientation_port_y + -0.0um, transmon_orientation_port_z + 567.287um) (transmon_orientation_port_x + 457.931um, transmon_orientation_port_y + -0.0um, transmon_orientation_port_z + 568.483um) (transmon_orientation_port_x + 459.626um, transmon_orientation_port_y + -0.0um, transmon_orientation_port_z + 569.714um) (transmon_orientation_port_x + 461.294um, transmon_orientation_port_y + -0.0um, transmon_orientation_port_z + 570.98um) (transmon_orientation_port_x + 462.935um, transmon_orientation_port_y + -0.0um, transmon_orientation_port_z + 572.281um) (transmon_orientation_port_x + 464.549um, transmon_orientation_port_y + -0.0um, transmon_orientation_port_z + 573.616um) (transmon_orientation_port_x + 466.135um, transmon_orientation_port_y + -0.0um, transmon_orientation_port_z + 574.985um) (transmon_orientation_port_x + 467.691um, transmon_orientation_port_y + -0.0um, transmon_orientation_port_z + 576.386um) (transmon_orientation_port_x + 469.218um, transmon_orientation_port_y + -0.0um, transmon_orientation_port_z + 577.82um) (transmon_orientation_port_x + 470.715um, transmon_orientation_port_y + -0.0um, transmon_orientation_port_z + 579.285um) (transmon_orientation_port_x + 472.18um, transmon_orientation_port_y + -0.0um, transmon_orientation_port_z + 580.782um) (transmon_orientation_port_x + 473.614um, transmon_orientation_port_y + -0.0um, transmon_orientation_port_z + 582.309um) (transmon_orientation_port_x + 475.015um, transmon_orientation_port_y + -0.0um, transmon_orientation_port_z + 583.865um) (transmon_orientation_port_x + 476.384um, transmon_orientation_port_y + -0.0um, transmon_orientation_port_z + 585.451um) (transmon_orientation_port_x + 477.719um, transmon_orientation_port_y + -0.0um, transmon_orientation_port_z + 587.065um) (transmon_orientation_port_x + 479.02um, transmon_orientation_port_y + -0.0um, transmon_orientation_port_z + 588.706um) (transmon_orientation_port_x + 480.286um, transmon_orientation_port_y + -0.0um, transmon_orientation_port_z + 590.374um) (transmon_orientation_port_x + 481.517um, transmon_orientation_port_y + -0.0um, transmon_orientation_port_z + 592.069um) (transmon_orientation_port_x + 482.713um, transmon_orientation_port_y + -0.0um, transmon_orientation_port_z + 593.789um) (transmon_orientation_port_x + 483.872um, transmon_orientation_port_y + -0.0um, transmon_orientation_port_z + 595.533um) (transmon_orientation_port_x + 484.994um, transmon_orientation_port_y + -0.0um, transmon_orientation_port_z + 597.302um) (transmon_orientation_port_x + 486.079um, transmon_orientation_port_y + -0.0um, transmon_orientation_port_z + 599.093um) (transmon_orientation_port_x + 487.126um, transmon_orientation_port_y + -0.0um, transmon_orientation_port_z + 600.907um) (transmon_orientation_port_x + 488.135um, transmon_orientation_port_y + -0.0um, transmon_orientation_port_z + 602.742um) (transmon_orientation_port_x + 489.106um, transmon_orientation_port_y + -0.0um, transmon_orientation_port_z + 604.598um) (transmon_orientation_port_x + 490.037um, transmon_orientation_port_y + -0.0um, transmon_orientation_port_z + 606.475um) (transmon_orientation_port_x + 490.929um, transmon_orientation_port_y + -0.0um, transmon_orientation_port_z + 608.37um) (transmon_orientation_port_x + 491.78um, transmon_orientation_port_y + -0.0um, transmon_orientation_port_z + 610.283um) (transmon_orientation_port_x + 492.592um, transmon_orientation_port_y + -0.0um, transmon_orientation_port_z + 612.214um) (transmon_orientation_port_x + 493.363um, transmon_orientation_port_y + -0.0um, transmon_orientation_port_z + 614.161um) (transmon_orientation_port_x + 494.093um, transmon_orientation_port_y + -0.0um, transmon_orientation_port_z + 616.124um) (transmon_orientation_port_x + 494.782um, transmon_orientation_port_y + -0.0um, transmon_orientation_port_z + 618.102um) (transmon_orientation_port_x + 495.429um, transmon_orientation_port_y + -0.0um, transmon_orientation_port_z + 620.094um) (transmon_orientation_port_x + 496.035um, transmon_orientation_port_y + -0.0um, transmon_orientation_port_z + 622.099um) (transmon_orientation_port_x + 496.598um, transmon_orientation_port_y + -0.0um, transmon_orientation_port_z + 624.117um) (transmon_orientation_port_x + 497.119um, transmon_orientation_port_y + -0.0um, transmon_orientation_port_z + 626.145um) (transmon_orientation_port_x + 497.597um, transmon_orientation_port_y + -0.0um, transmon_orientation_port_z + 628.184um) (transmon_orientation_port_x + 498.032um, transmon_orientation_port_y + -0.0um, transmon_orientation_port_z + 630.233um) (transmon_orientation_port_x + 498.425um, transmon_orientation_port_y + -0.0um, transmon_orientation_port_z + 632.291um) (transmon_orientation_port_x + 498.774um, transmon_orientation_port_y + -0.0um, transmon_orientation_port_z + 634.356um) (transmon_orientation_port_x + 499.08um, transmon_orientation_port_y + -0.0um, transmon_orientation_port_z + 636.428um) (transmon_orientation_port_x + 499.343um, transmon_orientation_port_y + -0.0um, transmon_orientation_port_z + 638.506um) (transmon_orientation_port_x + 499.562um, transmon_orientation_port_y + -0.0um, transmon_orientation_port_z + 640.589um) (transmon_orientation_port_x + 499.737um, transmon_orientation_port_y + -0.0um, transmon_orientation_port_z + 642.676um) (transmon_orientation_port_x + 499.868um, transmon_orientation_port_y + -0.0um, transmon_orientation_port_z + 644.766um)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, closed, covered)
  transmon_junction = rectangle(corner=(transmon_junction_left_arm_x - junction_width / 2, transmon_junction_left_arm_y, transmon_junction_left_arm_z), z_size=transmon_junction_right_arm_z - transmon_junction_left_arm_z, x_size=junction_width)
  transmon_junction_line = polyline((transmon_junction_left_arm_x, transmon_junction_left_arm_y, transmon_junction_left_arm_z) (transmon_junction_right_arm_x, transmon_junction_right_arm_y, transmon_junction_right_arm_z))
  readout = polyline((readout_e1_x + -800.0um, readout_e1_y + 9.153901961775739e-15um, readout_e1_z + -348.49200000000013um) (readout_e1_x + -798.961um, readout_e1_y + 9.142013331602882e-15um, readout_e1_z + -327.4250000000001um) (readout_e1_x + -795.202um, readout_e1_y + 9.099001434759989e-15um, readout_e1_z + -309.54500000000013um) (readout_e1_x + -788.371um, readout_e1_y + 9.020838554383875e-15um, readout_e1_z + -293.3060000000001um) (readout_e1_x + -778.5500000000001um, readout_e1_y + 8.908462965425625e-15um, readout_e1_z + -279.1510000000001um) (readout_e1_x + -766.242um, readout_e1_y + 8.767630183743704e-15um, readout_e1_z + -267.7450000000001um) (readout_e1_x + -751.095um, readout_e1_y + 8.594312492474934e-15um, readout_e1_z + -258.83100000000013um) (readout_e1_x + -734.34um, readout_e1_y + 8.402595458262993e-15um, readout_e1_z + -253.13100000000009um) (readout_e1_x + -715.249um, readout_e1_y + 8.184149030322668e-15um, readout_e1_z + -250.36200000000008um) (readout_e1_x + 700.0um, readout_e1_y + -8.009664216553764e-15um, readout_e1_z + -249.99999999999991um) (readout_e1_x + 700.0um, readout_e1_y + -8.009664216553766e-15um, readout_e1_z + -149.99999999999991um) (readout_e1_x + 45.19200000000002um, readout_e1_y + -5.171039218207091e-16um, readout_e1_z + -149.986um) (readout_e1_x + 25.073000000000018um, readout_e1_y + -2.868947298595017e-16um, readout_e1_z + -148.649um) (readout_e1_x + 7.730000000000018um, readout_e1_y + -8.844957770565605e-17um, readout_e1_z + -144.621um) (readout_e1_x + -9.121999999999984um, readout_e1_y + 1.0437736711914966e-16um, readout_e1_z + -136.989um) (readout_e1_x + -23.161999999999985um, readout_e1_y + 2.650283465483136e-16um, readout_e1_z + -126.459um) (readout_e1_x + -34.493999999999986um, readout_e1_y + 3.9469336783686673e-16um, readout_e1_z + -113.077um) (readout_e1_x + -42.826999999999984um, readout_e1_y + 4.90042699146213e-16um, readout_e1_z + -97.2um) (readout_e1_x + -47.28399999999999um, readout_e1_y + 5.410413754507558e-16um, readout_e1_z + -82.519um) (readout_e1_x + -49.556999999999995um, readout_e1_y + 5.6704989939965095e-16um, readout_e1_z + -66.425um) (readout_e1_x + -50.0um, readout_e1_y + 5.721188726109834e-16um, readout_e1_z + -6.123233995736766e-15um) (readout_e1_x + 50.0um, readout_e1_y + -5.721188726109834e-16um, readout_e1_z + 6.123233995736766e-15um) (readout_e1_x + 50.00000000000001um, readout_e1_y + -5.721188726109827e-16um, readout_e1_z + -49.99999999999999um) (readout_e1_x + 714.538um, readout_e1_y + -8.176013499954137e-15um, readout_e1_z + -50.31799999999991um) (readout_e1_x + 726.394um, readout_e1_y + -8.311674327027652e-15um, readout_e1_z + -51.570999999999906um) (readout_e1_x + 737.833um, readout_e1_y + -8.442563682703593e-15um, readout_e1_z + -54.02999999999991um) (readout_e1_x + 748.325um, readout_e1_y + -8.562617106932283e-15um, readout_e1_z + -57.628999999999905um) (readout_e1_x + 758.227um, readout_e1_y + -8.675919528464159e-15um, readout_e1_z + -62.48899999999991um) (readout_e1_x + 767.248um, readout_e1_y + -8.779141215460634e-15um, readout_e1_z + -68.5059999999999um) (readout_e1_x + 775.307um, readout_e1_y + -8.871355335348071e-15um, readout_e1_z + -75.6399999999999um) (readout_e1_x + 782.255um, readout_e1_y + -8.950856973886094e-15um, readout_e1_z + -83.7579999999999um) (readout_e1_x + 788.089um, readout_e1_y + -9.017611803942343e-15um, readout_e1_z + -92.7949999999999um) (readout_e1_x + 792.827um, readout_e1_y + -9.07182578831096e-15um, readout_e1_z + -102.7999999999999um) (readout_e1_x + 796.41um, readout_e1_y + -9.112823826722262e-15um, readout_e1_z + -113.8089999999999um) (readout_e1_x + 798.693um, readout_e1_y + -9.13894677444568e-15um, readout_e1_z + -125.3839999999999um) (readout_e1_x + 799.807um, readout_e1_y + -9.151693582927454e-15um, readout_e1_z + -137.87699999999992um) (readout_e1_x + 799.9540000000001um, readout_e1_y + -9.153375612412929e-15um, readout_e1_z + -257.2689999999999um) (readout_e1_x + 799.0790000000001um, readout_e1_y + -9.143363532142237e-15um, readout_e1_z + -271.5749999999999um) (readout_e1_x + 796.977um, readout_e1_y + -9.11931165473767e-15um, readout_e1_z + -283.8819999999999um) (readout_e1_x + 793.12um, readout_e1_y + -9.075178404904457e-15um, readout_e1_z + -296.4529999999999um) (readout_e1_x + 787.73um, readout_e1_y + -9.013503990436994e-15um, readout_e1_z + -307.8439999999999um) (readout_e1_x + 780.909um, readout_e1_y + -8.935455533835403e-15um, readout_e1_z + -317.9989999999999um) (readout_e1_x + 772.799um, readout_e1_y + -8.8426578526979e-15um, readout_e1_z + -326.7979999999999um) (readout_e1_x + 763.077um, readout_e1_y + -8.731415059107422e-15um, readout_e1_z + -334.4939999999999um) (readout_e1_x + 752.489um, readout_e1_y + -8.61026316664332e-15um, readout_e1_z + -340.51999999999987um) (readout_e1_x + 740.696um, readout_e1_y + -8.475323209349294e-15um, readout_e1_z + -345.1269999999999um) (readout_e1_x + 728.1030000000001um, readout_e1_y + -8.331229350093491e-15um, readout_e1_z + -348.1469999999999um) (readout_e1_x + 701.508um, readout_e1_y + -8.026919321751709e-15um, readout_e1_z + -349.9999999999999um) (readout_e1_x + -700.0um, readout_e1_y + 8.009664216553772e-15um, readout_e1_z + -350.0000000000001um) (readout_e1_x + -700.0um, readout_e1_y + 8.009664216553774e-15um, readout_e1_z + -450.0000000000001um) (readout_e1_x + 709.666um, readout_e1_y + -8.120266237006917e-15um, readout_e1_z + -450.1029999999999um) (readout_e1_x + 722.979um, readout_e1_y + -8.272598608028316e-15um, readout_e1_z + -451.0889999999999um) (readout_e1_x + 735.2620000000001um, readout_e1_y + -8.413145330273931e-15um, readout_e1_z + -453.3549999999999um) (readout_e1_x + 746.577um, readout_e1_y + -8.542615831145795e-15um, readout_e1_z + -456.9279999999999um) (readout_e1_x + 757.332um, readout_e1_y + -8.665678600644418e-15um, readout_e1_z + -461.9819999999999um) (readout_e1_x + 766.8710000000001um, readout_e1_y + -8.774827439161141e-15um, readout_e1_z + -468.2179999999999um) (readout_e1_x + 775.4240000000001um, readout_e1_y + -8.872694093509977e-15um, readout_e1_z + -475.7589999999999um) (readout_e1_x + 782.9030000000001um, readout_e1_y + -8.958271634475128e-15um, readout_e1_z + -484.6409999999999um) (readout_e1_x + 789.1220000000002um, readout_e1_y + -9.029431779850483e-15um, readout_e1_z + -494.7109999999999um) (readout_e1_x + 793.4510000000001um, readout_e1_y + -9.07896583184114e-15um, readout_e1_z + -504.4159999999999um) (readout_e1_x + 796.7020000000001um, readout_e1_y + -9.116165000938307e-15um, readout_e1_z + -514.9699999999999um) (readout_e1_x + 798.7920000000001um, readout_e1_y + -9.140079569813445e-15um, readout_e1_z + -526.1049999999999um) (readout_e1_x + 799.8350000000002um, readout_e1_y + -9.15201396949611e-15um, readout_e1_z + -538.5459999999999um) (readout_e1_x + 799.9390000000001um, readout_e1_y + -9.153203976751138e-15um, readout_e1_z + -658.026um) (readout_e1_x + 799.0330000000001um, readout_e1_y + -9.142837182779428e-15um, readout_e1_z + -671.973um) (readout_e1_x + 796.8140000000001um, readout_e1_y + -9.117446547212952e-15um, readout_e1_z + -684.5699999999999um) (readout_e1_x + 793.0720000000001um, readout_e1_y + -9.074629170786746e-15um, readout_e1_z + -696.5769999999999um) (readout_e1_x + 787.6570000000002um, readout_e1_y + -9.012668696882977e-15um, readout_e1_z + -707.9719999999999um) (readout_e1_x + 780.8100000000002um, readout_e1_y + -8.934322738467629e-15um, readout_e1_z + -718.1239999999999um) (readout_e1_x + 772.5570000000001um, readout_e1_y + -8.83988879735446e-15um, readout_e1_z + -727.0219999999999um) (readout_e1_x + 763.0770000000001um, readout_e1_y + -8.731415059107417e-15um, readout_e1_z + -734.4939999999999um) (readout_e1_x + 752.4890000000001um, readout_e1_y + -8.610263166643315e-15um, readout_e1_z + -740.5199999999999um) (readout_e1_x + 740.6960000000001um, readout_e1_y + -8.475323209349289e-15um, readout_e1_z + -745.127um) (readout_e1_x + 728.1030000000002um, readout_e1_y + -8.331229350093487e-15um, readout_e1_z + -748.1469999999999um) (readout_e1_x + 701.5080000000002um, readout_e1_y + -8.026919321751704e-15um, readout_e1_z + -749.9999999999999um) (readout_e1_x + -699.9999999999999um, readout_e1_y + 8.009664216553777e-15um, readout_e1_z + -750.0000000000001um) (readout_e1_x + -699.9999999999999um, readout_e1_y + 8.009664216553778e-15um, readout_e1_z + -850.0000000000001um) (readout_e1_x + 708.9550000000002um, readout_e1_y + -8.112130706638384e-15um, readout_e1_z + -850.0829999999999um) (readout_e1_x + 721.9730000000002um, readout_e1_y + -8.261087576311379e-15um, readout_e1_z + -850.9669999999999um) (readout_e1_x + 733.8820000000002um, readout_e1_y + -8.397354849389862e-15um, readout_e1_z + -853.0229999999999um) (readout_e1_x + 744.8430000000001um, readout_e1_y + -8.522774748643642e-15um, readout_e1_z + -856.2749999999999um) (readout_e1_x + 755.0340000000001um, readout_e1_y + -8.639384017259212e-15um, readout_e1_z + -860.7449999999999um) (readout_e1_x + 764.2200000000001um, readout_e1_y + -8.744493696535304e-15um, readout_e1_z + -866.2879999999999um) (readout_e1_x + 772.7990000000001um, readout_e1_y + -8.842657852697893e-15um, readout_e1_z + -873.2019999999999um) (readout_e1_x + 780.1090000000002um, readout_e1_y + -8.92630163187362e-15um, readout_e1_z + -881.0039999999999um) (readout_e1_x + 786.5300000000001um, readout_e1_y + -8.999773137494322e-15um, readout_e1_z + -890.1109999999999um) (readout_e1_x + 791.8400000000001um, readout_e1_y + -9.060532161765608e-15um, readout_e1_z + -900.4189999999999um) (readout_e1_x + 795.8040000000001um, readout_e1_y + -9.105889745986206e-15um, readout_e1_z + -911.5749999999999um) (readout_e1_x + 798.4290000000001um, readout_e1_y + -9.135925986798283e-15um, readout_e1_z + -923.6059999999999um) (readout_e1_x + 799.7270000000001um, readout_e1_y + -9.150778192731265e-15um, readout_e1_z + -936.2509999999999um) (readout_e1_x + 799.9540000000002um, readout_e1_y + -9.153375612412918e-15um, readout_e1_z + -1057.269um) (readout_e1_x + 799.1340000000001um, readout_e1_y + -9.143992862902098e-15um, readout_e1_z + -1071.0810000000001um) (readout_e1_x + 797.0820000000001um, readout_e1_y + -9.120513104370142e-15um, readout_e1_z + -1083.425um) (readout_e1_x + 793.4510000000001um, readout_e1_y + -9.078965831841133e-15um, readout_e1_z + -1095.584um) (readout_e1_x + 788.0890000000002um, readout_e1_y + -9.017611803942329e-15um, readout_e1_z + -1107.205um) (readout_e1_x + 781.4940000000001um, readout_e1_y + -8.942149324644941e-15um, readout_e1_z + -1117.248um) (readout_e1_x + 773.1620000000001um, readout_e1_y + -8.846811435713047e-15um, readout_e1_z + -1126.459um) (readout_e1_x + 763.7120000000001um, readout_e1_y + -8.73868096878957e-15um, readout_e1_z + -1134.063um) (readout_e1_x + 752.9970000000002um, readout_e1_y + -8.616075894389038e-15um, readout_e1_z + -1140.276um) (readout_e1_x + 741.2990000000001um, readout_e1_y + -8.482222962952971e-15um, readout_e1_z + -1144.9370000000001um) (readout_e1_x + 728.1030000000002um, readout_e1_y + -8.33122935009348e-15um, readout_e1_z + -1148.147um) (readout_e1_x + 701.5080000000002um, readout_e1_y + -8.026919321751698e-15um, readout_e1_z + -1150.0um) (readout_e1_x + -699.9999999999999um, readout_e1_y + 8.009664216553783e-15um, readout_e1_z + -1150.0um) (readout_e1_x + -699.9999999999999um, readout_e1_y + 8.009664216553785e-15um, readout_e1_z + -1250.0um) (readout_e1_x + 708.2560000000001um, readout_e1_y + -8.104132484799274e-15um, readout_e1_z + -1250.066um) (readout_e1_x + 731.5080000000002um, readout_e1_y + -8.370190645318288e-15um, readout_e1_z + -1252.501um) (readout_e1_x + 751.4750000000001um, readout_e1_y + -8.598660595906758e-15um, readout_e1_z + -1259.005um) (readout_e1_x + 760.4000000000001um, readout_e1_y + -8.700783814667817e-15um, readout_e1_z + -1263.7830000000001um) (readout_e1_x + 768.7470000000002um, readout_e1_y + -8.796293339261496e-15um, readout_e1_z + -1269.689um) (readout_e1_x + 776.0030000000002um, readout_e1_y + -8.879319230054801e-15um, readout_e1_z + -1276.357um) (readout_e1_x + 782.6270000000002um, readout_e1_y + -8.955113538298304e-15um, readout_e1_z + -1284.262um) (readout_e1_x + 789.2550000000001um, readout_e1_y + -9.030953616051616e-15um, readout_e1_z + -1294.9660000000001um) (readout_e1_x + 794.2070000000001um, readout_e1_y + -9.087616269195008e-15um, readout_e1_z + -1306.51um) (readout_e1_x + 797.6580000000001um, readout_e1_y + -9.127103913782618e-15um, readout_e1_z + -1319.272um) (readout_e1_x + 799.5010000000001um, readout_e1_y + -9.148192215427058e-15um, readout_e1_z + -1332.838um) (readout_e1_x + 799.9760000000002um, readout_e1_y + -9.153627344716859e-15um, readout_e1_z + -1455.8um) (readout_e1_x + 799.3040000000002um, readout_e1_y + -9.145938067068968e-15um, readout_e1_z + -1469.426um) (readout_e1_x + 797.5910000000002um, readout_e1_y + -9.126337274493315e-15um, readout_e1_z + -1481.061um) (readout_e1_x + 794.0350000000002um, readout_e1_y + -9.085648180273222e-15um, readout_e1_z + -1493.981um) (readout_e1_x + 788.8530000000003um, readout_e1_y + -9.026353780315821e-15um, readout_e1_z + -1505.8um) (readout_e1_x + 782.1610000000003um, readout_e1_y + -8.949781390405567e-15um, readout_e1_z + -1516.368um) (readout_e1_x + 774.0020000000003um, readout_e1_y + -8.856423032772906e-15um, readout_e1_z + -1525.656um) (readout_e1_x + 764.2200000000003um, readout_e1_y + -8.744493696535294e-15um, readout_e1_z + -1533.712um) (readout_e1_x + 753.5060000000002um, readout_e1_y + -8.621900064512211e-15um, readout_e1_z + -1540.027um) (readout_e1_x + 741.2990000000002um, readout_e1_y + -8.482222962952966e-15um, readout_e1_z + -1544.9370000000001um) (readout_e1_x + 728.5350000000002um, readout_e1_y + -8.336172457152834e-15um, readout_e1_z + -1548.0710000000001um) (readout_e1_x + 715.8790000000002um, readout_e1_y + -8.191357728117542e-15um, readout_e1_z + -1549.596um) (readout_e1_x + 701.5080000000003um, readout_e1_y + -8.026919321751693e-15um, readout_e1_z + -1550.0um) (readout_e1_x + -699.9999999999998um, readout_e1_y + 8.009664216553788e-15um, readout_e1_z + -1550.0um) (readout_e1_x + -699.9999999999998um, readout_e1_y + 8.00966421655379e-15um, readout_e1_z + -1650.0um) (readout_e1_x + 707.2690000000002um, readout_e1_y + -8.092838858253929e-15um, readout_e1_z + -1650.046um) (readout_e1_x + 728.1030000000003um, readout_e1_y + -8.331229350093474e-15um, readout_e1_z + -1651.853um) (readout_e1_x + 746.5770000000002um, readout_e1_y + -8.54261583114578e-15um, readout_e1_z + -1656.928um) (readout_e1_x + 763.0770000000002um, readout_e1_y + -8.731415059107404e-15um, readout_e1_z + -1665.506um) (readout_e1_x + 777.0220000000003um, readout_e1_y + -8.890979012678608e-15um, readout_e1_z + -1677.443um) (readout_e1_x + 785.4140000000002um, readout_e1_y + -8.987003444257633e-15um, readout_e1_z + -1688.324um) (readout_e1_x + 792.0020000000003um, readout_e1_y + -9.062385826912857e-15um, readout_e1_z + -1700.796um) (readout_e1_x + 796.5290000000002um, readout_e1_y + -9.114185469639056e-15um, readout_e1_z + -1714.275um) (readout_e1_x + 799.1970000000002um, readout_e1_y + -9.144713732681578e-15um, readout_e1_z + -1729.508um) (readout_e1_x + 799.9920000000002um, readout_e1_y + -9.153810422756092e-15um, readout_e1_z + -1746.019um) (readout_e1_x + 799.9860000000002um, readout_e1_y + -9.153741768491377e-15um, readout_e1_z + -1854.808um) (readout_e1_x + 798.0710000000003um, readout_e1_y + -9.131829615670376e-15um, readout_e1_z + -1878.535um) (readout_e1_x + 794.8200000000003um, readout_e1_y + -9.09463044657321e-15um, readout_e1_z + -1891.662um) (readout_e1_x + 789.8380000000002um, readout_e1_y + -9.037624522106251e-15um, readout_e1_z + -1903.887um) (readout_e1_x + 783.2660000000002um, readout_e1_y + -8.962425217490262e-15um, readout_e1_z + -1914.853um) (readout_e1_x + 775.0720000000002um, readout_e1_y + -8.868666376646774e-15um, readout_e1_z + -1924.598um) (readout_e1_x + 765.3590000000003um, readout_e1_y + -8.757526564453365e-15um, readout_e1_z + -1932.903um) (readout_e1_x + 754.5240000000002um, readout_e1_y + -8.633548404758566e-15um, readout_e1_z + -1939.517um) (readout_e1_x + 742.5130000000003um, readout_e1_y + -8.496114009179955e-15um, readout_e1_z + -1944.54um) (readout_e1_x + 729.2970000000003um, readout_e1_y + -8.34489154877142e-15um, readout_e1_z + -1947.933um) (readout_e1_x + 717.2540000000002um, readout_e1_y + -8.207090997114338e-15um, readout_e1_z + -1949.4940000000001um) (readout_e1_x + 702.2010000000002um, readout_e1_y + -8.034848889326076e-15um, readout_e1_z + -1949.999um) (readout_e1_x + -699.9999999999998um, readout_e1_y + 8.009664216553794e-15um, readout_e1_z + -1950.0um) (readout_e1_x + -699.9999999999998um, readout_e1_y + 8.009664216553796e-15um, readout_e1_z + -2050.0um) (readout_e1_x + 705.8000000000003um, readout_e1_y + -8.076030005776613e-15um, readout_e1_z + -2050.024um) (readout_e1_x + 724.6160000000002um, readout_e1_y + -8.291329779917577e-15um, readout_e1_z + -2051.3070000000002um) (readout_e1_x + 741.0580000000002um, readout_e1_y + -8.479465349986973e-15um, readout_e1_z + -2054.987um) (readout_e1_x + 755.8000000000003um, readout_e1_y + -8.648148878387597e-15um, readout_e1_z + -2061.147um) (readout_e1_x + 769.1200000000002um, readout_e1_y + -8.800561346051162e-15um, readout_e1_z + -2069.992um) (readout_e1_x + 780.0080000000003um, readout_e1_y + -8.92514595175093e-15um, readout_e1_z + -2080.88um) (readout_e1_x + 788.6480000000003um, readout_e1_y + -9.024008092938108e-15um, readout_e1_z + -2093.817um) (readout_e1_x + 794.9370000000002um, readout_e1_y + -9.095969204735117e-15um, readout_e1_z + -2108.701um) (readout_e1_x + 798.6490000000002um, readout_e1_y + -9.138443309837755e-15um, readout_e1_z + -2125.073um) (readout_e1_x + 800.0000000000002um, readout_e1_y + -9.153901961775704e-15um, readout_e1_z + -2148.492um) (readout_e1_x + 799.9800000000002um, readout_e1_y + -9.153673114226659e-15um, readout_e1_z + -2255.443um) (readout_e1_x + 798.6490000000002um, readout_e1_y + -9.138443309837752e-15um, readout_e1_z + -2274.927um) (readout_e1_x + 795.7020000000002um, readout_e1_y + -9.104722623486062e-15um, readout_e1_z + -2288.781um) (readout_e1_x + 790.9950000000002um, readout_e1_y + -9.050863352818463e-15um, readout_e1_z + -2301.475um) (readout_e1_x + 784.4940000000003um, readout_e1_y + -8.976476457001584e-15um, readout_e1_z + -2313.077um) (readout_e1_x + 776.3460000000003um, readout_e1_y + -8.883243965520897e-15um, readout_e1_z + -2323.282um) (readout_e1_x + 766.6200000000003um, readout_e1_y + -8.77195540242061e-15um, readout_e1_z + -2331.972um) (readout_e1_x + 755.4170000000004um, readout_e1_y + -8.643766447823393e-15um, readout_e1_z + -2339.055um) (readout_e1_x + 742.8790000000004um, readout_e1_y + -8.500301919327462e-15um, readout_e1_z + -2344.417um) (readout_e1_x + 729.7350000000004um, readout_e1_y + -8.349903310095487e-15um, readout_e1_z + -2347.851um) (readout_e1_x + 717.2540000000004um, readout_e1_y + -8.207090997114333e-15um, readout_e1_z + -2349.494um) (readout_e1_x + 702.2010000000004um, readout_e1_y + -8.034848889326071e-15um, readout_e1_z + -2349.9990000000003um) (readout_e1_x + -699.9999999999997um, readout_e1_y + 8.009664216553799e-15um, readout_e1_z + -2350.0um) (readout_e1_x + -699.9999999999997um, readout_e1_y + 8.0096642165538e-15um, readout_e1_z + -2450.0um) (readout_e1_x + 704.8080000000003um, readout_e1_y + -8.064679167344006e-15um, readout_e1_z + -2450.014um) (readout_e1_x + 719.7150000000004um, readout_e1_y + -8.235250688024244e-15um, readout_e1_z + -2450.724um) (readout_e1_x + 732.5190000000003um, readout_e1_y + -8.381758888922465e-15um, readout_e1_z + -2452.716um) (readout_e1_x + 744.8430000000003um, readout_e1_y + -8.52277474864362e-15um, readout_e1_z + -2456.275um) (readout_e1_x + 756.1830000000003um, readout_e1_y + -8.652531308951792e-15um, readout_e1_z + -2461.352um) (readout_e1_x + 771.0950000000004um, readout_e1_y + -8.82316004151929e-15um, readout_e1_z + -2471.664um) (readout_e1_x + 782.9030000000004um, readout_e1_y + -8.958271634475101e-15um, readout_e1_z + -2484.641um) (readout_e1_x + 791.7310000000003um, readout_e1_y + -9.059284942623294e-15um, readout_e1_z + -2500.167um) (readout_e1_x + 797.4290000000003um, readout_e1_y + -9.124483609346041e-15um, readout_e1_z + -2518.157um) (readout_e1_x + 799.2470000000004um, readout_e1_y + -9.145285851554178e-15um, readout_e1_z + -2529.995um) (readout_e1_x + 799.9640000000004um, readout_e1_y + -9.15349003618742e-15um, readout_e1_z + -2543.326um) (readout_e1_x + 799.5960000000003um, readout_e1_y + -9.149279241285e-15um, readout_e1_z + -2665.879um) (readout_e1_x + 797.7020000000003um, readout_e1_y + -9.127607378390496e-15um, readout_e1_z + -2680.506um) (readout_e1_x + 794.0350000000003um, readout_e1_y + -9.085648180273206e-15um, readout_e1_z + -2693.981um) (readout_e1_x + 788.3710000000003um, readout_e1_y + -9.020838554383834e-15um, readout_e1_z + -2706.694um) (readout_e1_x + 781.1050000000004um, readout_e1_y + -8.937698239816006e-15um, readout_e1_z + -2717.7490000000003um) (readout_e1_x + 772.0720000000003um, readout_e1_y + -8.834339244290105e-15um, readout_e1_z + -2727.466um) (readout_e1_x + 761.9310000000004um, readout_e1_y + -8.718302094547145e-15um, readout_e1_z + -2735.25um) (readout_e1_x + 749.9590000000004um, readout_e1_y + -8.581313951689172e-15um, readout_e1_z + -2741.676um) (readout_e1_x + 736.8920000000004um, readout_e1_y + -8.431796405521017e-15um, readout_e1_z + -2746.226um) (readout_e1_x + 721.0810000000004um, readout_e1_y + -8.250880975623971e-15um, readout_e1_z + -2749.134um) (readout_e1_x + 702.5870000000003um, readout_e1_y + -8.03926564702262e-15um, readout_e1_z + -2749.998um) (readout_e1_x + -699.9999999999997um, readout_e1_y + 8.009664216553805e-15um, readout_e1_z + -2750.0um) (readout_e1_x + -699.9999999999997um, readout_e1_y + 8.009664216553807e-15um, readout_e1_z + -2850.0um) (readout_e1_x + 702.2010000000004um, readout_e1_y + -8.034848889326063e-15um, readout_e1_z + -2850.001um) (readout_e1_x + 717.6260000000003um, readout_e1_y + -8.211347561526551e-15um, readout_e1_z + -2850.536um) (readout_e1_x + 730.5060000000003um, readout_e1_y + -8.35872538311114e-15um, readout_e1_z + -2852.2980000000002um) (readout_e1_x + 744.5960000000003um, readout_e1_y + -8.519948481412916e-15um, readout_e1_z + -2856.185um) (readout_e1_x + 757.2050000000004um, readout_e1_y + -8.664225418707954e-15um, readout_e1_z + -2861.911um) (readout_e1_x + 768.4980000000004um, readout_e1_y + -8.79344418727587e-15um, readout_e1_z + -2869.4880000000003um) (readout_e1_x + 778.3360000000004um, readout_e1_y + -8.906014296650807e-15um, readout_e1_z + -2878.905um) (readout_e1_x + 786.5300000000003um, readout_e1_y + -8.999773137494295e-15um, readout_e1_z + -2890.111um) (readout_e1_x + 792.6770000000004um, readout_e1_y + -9.07010943169309e-15um, readout_e1_z + -2902.426um) (readout_e1_x + 796.9770000000003um, readout_e1_y + -9.119311654737634e-15um, readout_e1_z + -2916.118um) (readout_e1_x + 799.3490000000004um, readout_e1_y + -9.146452974054299e-15um, readout_e1_z + -2931.052um) (readout_e1_x + 799.9760000000003um, readout_e1_y + -9.153627344716838e-15um, readout_e1_z + -3055.8um) (readout_e1_x + 799.3040000000003um, readout_e1_y + -9.145938067068948e-15um, readout_e1_z + -3069.426um) (readout_e1_x + 797.5910000000003um, readout_e1_y + -9.126337274493293e-15um, readout_e1_z + -3081.061um) (readout_e1_x + 792.0020000000004um, readout_e1_y + -9.062385826912838e-15um, readout_e1_z + -3099.204um) (readout_e1_x + 783.2660000000003um, readout_e1_y + -8.962425217490246e-15um, readout_e1_z + -3114.853um) (readout_e1_x + 771.7060000000004um, readout_e1_y + -8.830151334142588e-15um, readout_e1_z + -3127.795um) (readout_e1_x + 757.2050000000004um, readout_e1_y + -8.66422541870795e-15um, readout_e1_z + -3138.089um) (readout_e1_x + 746.2040000000004um, readout_e1_y + -8.538347824356082e-15um, readout_e1_z + -3143.216um) (readout_e1_x + 734.3400000000004um, readout_e1_y + -8.402595458262948e-15um, readout_e1_z + -3146.869um) (readout_e1_x + 721.5750000000004um, readout_e1_y + -8.256533510085364e-15um, readout_e1_z + -3149.079um) (readout_e1_x + 707.2690000000003um, readout_e1_y + -8.092838858253909e-15um, readout_e1_z + -3149.954um) (readout_e1_x + 50.000000000000384um, readout_e1_y + -5.721188726109406e-16um, readout_e1_z + -3150.0um) (readout_e1_x + 50.00000000000039um, readout_e1_y + -5.721188726109399e-16um, readout_e1_z + -3200.0um) (readout_e1_x + -49.99999999999961um, readout_e1_y + 5.721188726110269e-16um, readout_e1_z + -3200.0um) (readout_e1_x + -49.55699999999962um, readout_e1_y + 5.670498993996927e-16um, readout_e1_z + -3133.5750000000003um) (readout_e1_x + -47.283999999999615um, readout_e1_y + 5.410413754507971e-16um, readout_e1_z + -3117.481um) (readout_e1_x + -42.82699999999962um, readout_e1_y + 4.900426991462539e-16um, readout_e1_z + -3102.8um) (readout_e1_x + -34.49399999999962um, readout_e1_y + 3.9469336783690715e-16um, readout_e1_z + -3086.9230000000002um) (readout_e1_x + -23.161999999999622um, readout_e1_y + 2.650283465483537e-16um, readout_e1_z + -3073.541um) (readout_e1_x + -9.121999999999625um, readout_e1_y + 1.0437736711918945e-16um, readout_e1_z + -3063.011um) (readout_e1_x + 7.730000000000374um, readout_e1_y + -8.844957770561649e-17um, readout_e1_z + -3055.379um) (readout_e1_x + 25.073000000000373um, readout_e1_y + -2.8689472985946226e-16um, readout_e1_z + -3051.351um) (readout_e1_x + 45.19200000000038um, readout_e1_y + -5.171039218206696e-16um, readout_e1_z + -3050.014um) (readout_e1_x + 700.0000000000003um, readout_e1_y + -8.009664216553726e-15um, readout_e1_z + -3050.0um) (readout_e1_x + 700.0000000000003um, readout_e1_y + -8.009664216553728e-15um, readout_e1_z + -2950.0um) (readout_e1_x + -709.4269999999997um, readout_e1_y + 8.117531508795882e-15um, readout_e1_z + -2949.904um) (readout_e1_x + -722.5749999999997um, readout_e1_y + 8.267975887537666e-15um, readout_e1_z + -2948.9610000000002um) (readout_e1_x + -734.5699999999997um, readout_e1_y + 8.405227205077041e-15um, readout_e1_z + -2946.814um) (readout_e1_x + -746.2039999999997um, readout_e1_y + 8.538347824356164e-15um, readout_e1_z + -2943.216um) (readout_e1_x + -756.4379999999996um, readout_e1_y + 8.65544911520218e-15um, readout_e1_z + -2938.51um) (readout_e1_x + -766.2419999999996um, readout_e1_y + 8.76763018374374e-15um, readout_e1_z + -2932.255um) (readout_e1_x + -774.5979999999997um, readout_e1_y + 8.86324268973449e-15um, readout_e1_z + -2925.072um) (readout_e1_x + -781.9719999999996um, readout_e1_y + 8.947618781067157e-15um, readout_e1_z + -2916.62um) (readout_e1_x + -788.0889999999997um, readout_e1_y + 9.017611803942384e-15um, readout_e1_z + -2907.205um) (readout_e1_x + -792.8269999999997um, readout_e1_y + 9.071825788311e-15um, readout_e1_z + -2897.2000000000003um) (readout_e1_x + -796.4099999999996um, readout_e1_y + 9.112823826722303e-15um, readout_e1_z + -2886.1910000000003um) (readout_e1_x + -798.6929999999996um, readout_e1_y + 9.138946774445722e-15um, readout_e1_z + -2874.616um) (readout_e1_x + -799.8069999999997um, readout_e1_y + 9.151693582927495e-15um, readout_e1_z + -2862.123um) (readout_e1_x + -799.9539999999997um, readout_e1_y + 9.15337561241297e-15um, readout_e1_z + -2742.731um) (readout_e1_x + -799.0789999999997um, readout_e1_y + 9.143363532142278e-15um, readout_e1_z + -2728.425um) (readout_e1_x + -796.9769999999996um, readout_e1_y + 9.11931165473771e-15um, readout_e1_z + -2716.118um) (readout_e1_x + -793.1199999999997um, readout_e1_y + 9.075178404904498e-15um, readout_e1_z + -2703.547um) (readout_e1_x + -787.7299999999997um, readout_e1_y + 9.013503990437035e-15um, readout_e1_z + -2692.156um) (readout_e1_x + -780.9089999999997um, readout_e1_y + 8.935455533835444e-15um, readout_e1_z + -2682.001um) (readout_e1_x + -772.7989999999996um, readout_e1_y + 8.842657852697942e-15um, readout_e1_z + -2673.202um) (readout_e1_x + -763.0769999999997um, readout_e1_y + 8.731415059107463e-15um, readout_e1_z + -2665.506um) (readout_e1_x + -752.4889999999997um, readout_e1_y + 8.610263166643361e-15um, readout_e1_z + -2659.48um) (readout_e1_x + -740.6959999999997um, readout_e1_y + 8.475323209349335e-15um, readout_e1_z + -2654.873um) (readout_e1_x + -728.1029999999997um, readout_e1_y + 8.331229350093532e-15um, readout_e1_z + -2651.853um) (readout_e1_x + -701.5079999999997um, readout_e1_y + 8.02691932175175e-15um, readout_e1_z + -2650.0um) (readout_e1_x + 700.0000000000003um, readout_e1_y + -8.009664216553731e-15um, readout_e1_z + -2650.0um) (readout_e1_x + 700.0000000000003um, readout_e1_y + -8.009664216553733e-15um, readout_e1_z + -2550.0um) (readout_e1_x + -708.2559999999996um, readout_e1_y + 8.104132484799326e-15um, readout_e1_z + -2549.934um) (readout_e1_x + -731.0609999999997um, readout_e1_y + 8.365075902597197e-15um, readout_e1_z + -2547.591um) (readout_e1_x + -750.5899999999997um, readout_e1_y + 8.588534091861595e-15um, readout_e1_z + -2541.397um) (readout_e1_x + -759.8889999999997um, readout_e1_y + 8.694936759789786e-15um, readout_e1_z + -2536.53um) (readout_e1_x + -767.9989999999997um, readout_e1_y + 8.787734440927286e-15um, readout_e1_z + -2530.909um) (readout_e1_x + -775.4239999999996um, readout_e1_y + 8.872694093510018e-15um, readout_e1_z + -2524.241um) (readout_e1_x + -781.7819999999997um, readout_e1_y + 8.94544472935123e-15um, readout_e1_z + -2516.871um) (readout_e1_x + -788.6479999999997um, readout_e1_y + 9.024008092938171e-15um, readout_e1_z + -2506.183um) (readout_e1_x + -794.0349999999996um, readout_e1_y + 9.085648180273276e-15um, readout_e1_z + -2493.981um) (readout_e1_x + -797.5909999999997um, readout_e1_y + 9.126337274493369e-15um, readout_e1_z + -2481.061um) (readout_e1_x + -799.4939999999997um, readout_e1_y + 9.148112118784944e-15um, readout_e1_z + -2467.254um) (readout_e1_x + -799.9759999999997um, readout_e1_y + 9.153627344716911e-15um, readout_e1_z + -2344.2000000000003um) (readout_e1_x + -797.6579999999998um, readout_e1_y + 9.127103913782667e-15um, readout_e1_z + -2319.272um) (readout_e1_x + -794.2069999999998um, readout_e1_y + 9.087616269195056e-15um, readout_e1_z + -2306.51um) (readout_e1_x + -789.0549999999998um, readout_e1_y + 9.028665140561222e-15um, readout_e1_z + -2294.583um) (readout_e1_x + -782.2549999999998um, readout_e1_y + 8.950856973886127e-15um, readout_e1_z + -2283.7580000000003um) (readout_e1_x + -774.2409999999998um, readout_e1_y + 8.859157760984039e-15um, readout_e1_z + -2274.576um) (readout_e1_x + -764.8529999999998um, readout_e1_y + 8.7517367214626e-15um, readout_e1_z + -2266.734um) (readout_e1_x + -753.8869999999998um, readout_e1_y + 8.626259610321559e-15um, readout_e1_z + -2260.1620000000003um) (readout_e1_x + -741.9049999999997um, readout_e1_y + 8.489157043689061e-15um, readout_e1_z + -2255.259um) (readout_e1_x + -728.9689999999998um, readout_e1_y + 8.341138448967148e-15um, readout_e1_z + -2252.007um) (readout_e1_x + -716.4249999999998um, readout_e1_y + 8.197605266206505e-15um, readout_e1_z + -2250.443um) (readout_e1_x + -701.5079999999998um, readout_e1_y + 8.026919321751744e-15um, readout_e1_z + -2250.0um) (readout_e1_x + 700.0000000000002um, readout_e1_y + -8.009664216553737e-15um, readout_e1_z + -2250.0um) (readout_e1_x + 700.0000000000002um, readout_e1_y + -8.009664216553737e-15um, readout_e1_z + -2150.0um) (readout_e1_x + -705.7999999999998um, readout_e1_y + 8.076030005776671e-15um, readout_e1_z + -2149.976um) (readout_e1_x + -724.3059999999998um, readout_e1_y + 8.287782642907448e-15um, readout_e1_z + -2148.736um) (readout_e1_x + -740.3349999999998um, readout_e1_y + 8.471192511089075e-15um, readout_e1_z + -2145.239um) (readout_e1_x + -755.0339999999998um, readout_e1_y + 8.639384017259252e-15um, readout_e1_z + -2139.255um) (readout_e1_x + -768.1239999999998um, readout_e1_y + 8.789164738108809e-15um, readout_e1_z + -2130.81um) (readout_e1_x + -779.2869999999998um, readout_e1_y + 8.916895997607936e-15um, readout_e1_z + -2119.987um) (readout_e1_x + -788.1599999999997um, readout_e1_y + 9.01842421274148e-15um, readout_e1_z + -2107.077um) (readout_e1_x + -794.6209999999998um, readout_e1_y + 9.092353413460272e-15um, readout_e1_z + -2092.27um) (readout_e1_x + -798.5419999999998um, readout_e1_y + 9.137218975450426e-15um, readout_e1_z + -2075.657um) (readout_e1_x + -799.9999999999998um, readout_e1_y + 9.153901961775763e-15um, readout_e1_z + -2051.5080000000003um)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, closed, covered)
  purcell = polyline((purcell_e1_x + -800.0um, purcell_e1_y + 9.153901961775739e-15um, purcell_e1_z + -348.49200000000013um) (purcell_e1_x + -798.961um, purcell_e1_y + 9.142013331602882e-15um, purcell_e1_z + -327.4250000000001um) (purcell_e1_x + -795.202um, purcell_e1_y + 9.099001434759989e-15um, purcell_e1_z + -309.54500000000013um) (purcell_e1_x + -788.371um, purcell_e1_y + 9.020838554383875e-15um, purcell_e1_z + -293.3060000000001um) (purcell_e1_x + -778.5500000000001um, purcell_e1_y + 8.908462965425625e-15um, purcell_e1_z + -279.1510000000001um) (purcell_e1_x + -766.242um, purcell_e1_y + 8.767630183743704e-15um, purcell_e1_z + -267.7450000000001um) (purcell_e1_x + -751.095um, purcell_e1_y + 8.594312492474934e-15um, purcell_e1_z + -258.83100000000013um) (purcell_e1_x + -734.34um, purcell_e1_y + 8.402595458262993e-15um, purcell_e1_z + -253.13100000000009um) (purcell_e1_x + -715.249um, purcell_e1_y + 8.184149030322668e-15um, purcell_e1_z + -250.36200000000008um) (purcell_e1_x + 700.0um, purcell_e1_y + -8.009664216553764e-15um, purcell_e1_z + -249.99999999999991um) (purcell_e1_x + 700.0um, purcell_e1_y + -8.009664216553766e-15um, purcell_e1_z + -149.99999999999991um) (purcell_e1_x + 45.19200000000002um, purcell_e1_y + -5.171039218207091e-16um, purcell_e1_z + -149.986um) (purcell_e1_x + 25.073000000000018um, purcell_e1_y + -2.868947298595017e-16um, purcell_e1_z + -148.649um) (purcell_e1_x + 7.730000000000018um, purcell_e1_y + -8.844957770565605e-17um, purcell_e1_z + -144.621um) (purcell_e1_x + -9.121999999999984um, purcell_e1_y + 1.0437736711914966e-16um, purcell_e1_z + -136.989um) (purcell_e1_x + -23.161999999999985um, purcell_e1_y + 2.650283465483136e-16um, purcell_e1_z + -126.459um) (purcell_e1_x + -34.493999999999986um, purcell_e1_y + 3.9469336783686673e-16um, purcell_e1_z + -113.077um) (purcell_e1_x + -42.826999999999984um, purcell_e1_y + 4.90042699146213e-16um, purcell_e1_z + -97.2um) (purcell_e1_x + -47.28399999999999um, purcell_e1_y + 5.410413754507558e-16um, purcell_e1_z + -82.519um) (purcell_e1_x + -49.556999999999995um, purcell_e1_y + 5.6704989939965095e-16um, purcell_e1_z + -66.425um) (purcell_e1_x + -50.0um, purcell_e1_y + 5.721188726109834e-16um, purcell_e1_z + -6.123233995736766e-15um) (purcell_e1_x + 50.0um, purcell_e1_y + -5.721188726109834e-16um, purcell_e1_z + 6.123233995736766e-15um) (purcell_e1_x + 50.00000000000001um, purcell_e1_y + -5.721188726109827e-16um, purcell_e1_z + -49.99999999999999um) (purcell_e1_x + 714.538um, purcell_e1_y + -8.176013499954137e-15um, purcell_e1_z + -50.31799999999991um) (purcell_e1_x + 726.394um, purcell_e1_y + -8.311674327027652e-15um, purcell_e1_z + -51.570999999999906um) (purcell_e1_x + 737.833um, purcell_e1_y + -8.442563682703593e-15um, purcell_e1_z + -54.02999999999991um) (purcell_e1_x + 748.325um, purcell_e1_y + -8.562617106932283e-15um, purcell_e1_z + -57.628999999999905um) (purcell_e1_x + 758.227um, purcell_e1_y + -8.675919528464159e-15um, purcell_e1_z + -62.48899999999991um) (purcell_e1_x + 767.248um, purcell_e1_y + -8.779141215460634e-15um, purcell_e1_z + -68.5059999999999um) (purcell_e1_x + 775.307um, purcell_e1_y + -8.871355335348071e-15um, purcell_e1_z + -75.6399999999999um) (purcell_e1_x + 782.255um, purcell_e1_y + -8.950856973886094e-15um, purcell_e1_z + -83.7579999999999um) (purcell_e1_x + 788.089um, purcell_e1_y + -9.017611803942343e-15um, purcell_e1_z + -92.7949999999999um) (purcell_e1_x + 792.827um, purcell_e1_y + -9.07182578831096e-15um, purcell_e1_z + -102.7999999999999um) (purcell_e1_x + 796.41um, purcell_e1_y + -9.112823826722262e-15um, purcell_e1_z + -113.8089999999999um) (purcell_e1_x + 798.693um, purcell_e1_y + -9.13894677444568e-15um, purcell_e1_z + -125.3839999999999um) (purcell_e1_x + 799.807um, purcell_e1_y + -9.151693582927454e-15um, purcell_e1_z + -137.87699999999992um) (purcell_e1_x + 799.9540000000001um, purcell_e1_y + -9.153375612412929e-15um, purcell_e1_z + -257.2689999999999um) (purcell_e1_x + 799.0790000000001um, purcell_e1_y + -9.143363532142237e-15um, purcell_e1_z + -271.5749999999999um) (purcell_e1_x + 796.977um, purcell_e1_y + -9.11931165473767e-15um, purcell_e1_z + -283.8819999999999um) (purcell_e1_x + 793.12um, purcell_e1_y + -9.075178404904457e-15um, purcell_e1_z + -296.4529999999999um) (purcell_e1_x + 787.73um, purcell_e1_y + -9.013503990436994e-15um, purcell_e1_z + -307.8439999999999um) (purcell_e1_x + 780.909um, purcell_e1_y + -8.935455533835403e-15um, purcell_e1_z + -317.9989999999999um) (purcell_e1_x + 772.799um, purcell_e1_y + -8.8426578526979e-15um, purcell_e1_z + -326.7979999999999um) (purcell_e1_x + 763.077um, purcell_e1_y + -8.731415059107422e-15um, purcell_e1_z + -334.4939999999999um) (purcell_e1_x + 752.489um, purcell_e1_y + -8.61026316664332e-15um, purcell_e1_z + -340.51999999999987um) (purcell_e1_x + 740.696um, purcell_e1_y + -8.475323209349294e-15um, purcell_e1_z + -345.1269999999999um) (purcell_e1_x + 728.1030000000001um, purcell_e1_y + -8.331229350093491e-15um, purcell_e1_z + -348.1469999999999um) (purcell_e1_x + 701.508um, purcell_e1_y + -8.026919321751709e-15um, purcell_e1_z + -349.9999999999999um) (purcell_e1_x + -700.0um, purcell_e1_y + 8.009664216553772e-15um, purcell_e1_z + -350.0000000000001um) (purcell_e1_x + -700.0um, purcell_e1_y + 8.009664216553774e-15um, purcell_e1_z + -450.0000000000001um) (purcell_e1_x + 709.666um, purcell_e1_y + -8.120266237006917e-15um, purcell_e1_z + -450.1029999999999um) (purcell_e1_x + 722.979um, purcell_e1_y + -8.272598608028316e-15um, purcell_e1_z + -451.0889999999999um) (purcell_e1_x + 735.2620000000001um, purcell_e1_y + -8.413145330273931e-15um, purcell_e1_z + -453.3549999999999um) (purcell_e1_x + 746.577um, purcell_e1_y + -8.542615831145795e-15um, purcell_e1_z + -456.9279999999999um) (purcell_e1_x + 757.332um, purcell_e1_y + -8.665678600644418e-15um, purcell_e1_z + -461.9819999999999um) (purcell_e1_x + 766.8710000000001um, purcell_e1_y + -8.774827439161141e-15um, purcell_e1_z + -468.2179999999999um) (purcell_e1_x + 775.4240000000001um, purcell_e1_y + -8.872694093509977e-15um, purcell_e1_z + -475.7589999999999um) (purcell_e1_x + 782.9030000000001um, purcell_e1_y + -8.958271634475128e-15um, purcell_e1_z + -484.6409999999999um) (purcell_e1_x + 789.1220000000002um, purcell_e1_y + -9.029431779850483e-15um, purcell_e1_z + -494.7109999999999um) (purcell_e1_x + 793.4510000000001um, purcell_e1_y + -9.07896583184114e-15um, purcell_e1_z + -504.4159999999999um) (purcell_e1_x + 796.7020000000001um, purcell_e1_y + -9.116165000938307e-15um, purcell_e1_z + -514.9699999999999um) (purcell_e1_x + 798.7920000000001um, purcell_e1_y + -9.140079569813445e-15um, purcell_e1_z + -526.1049999999999um) (purcell_e1_x + 799.8350000000002um, purcell_e1_y + -9.15201396949611e-15um, purcell_e1_z + -538.5459999999999um) (purcell_e1_x + 799.9390000000001um, purcell_e1_y + -9.153203976751138e-15um, purcell_e1_z + -658.026um) (purcell_e1_x + 799.0330000000001um, purcell_e1_y + -9.142837182779428e-15um, purcell_e1_z + -671.973um) (purcell_e1_x + 796.8140000000001um, purcell_e1_y + -9.117446547212952e-15um, purcell_e1_z + -684.5699999999999um) (purcell_e1_x + 793.0720000000001um, purcell_e1_y + -9.074629170786746e-15um, purcell_e1_z + -696.5769999999999um) (purcell_e1_x + 787.6570000000002um, purcell_e1_y + -9.012668696882977e-15um, purcell_e1_z + -707.9719999999999um) (purcell_e1_x + 780.8100000000002um, purcell_e1_y + -8.934322738467629e-15um, purcell_e1_z + -718.1239999999999um) (purcell_e1_x + 772.5570000000001um, purcell_e1_y + -8.83988879735446e-15um, purcell_e1_z + -727.0219999999999um) (purcell_e1_x + 763.0770000000001um, purcell_e1_y + -8.731415059107417e-15um, purcell_e1_z + -734.4939999999999um) (purcell_e1_x + 752.4890000000001um, purcell_e1_y + -8.610263166643315e-15um, purcell_e1_z + -740.5199999999999um) (purcell_e1_x + 740.6960000000001um, purcell_e1_y + -8.475323209349289e-15um, purcell_e1_z + -745.127um) (purcell_e1_x + 728.1030000000002um, purcell_e1_y + -8.331229350093487e-15um, purcell_e1_z + -748.1469999999999um) (purcell_e1_x + 701.5080000000002um, purcell_e1_y + -8.026919321751704e-15um, purcell_e1_z + -749.9999999999999um) (purcell_e1_x + -699.9999999999999um, purcell_e1_y + 8.009664216553777e-15um, purcell_e1_z + -750.0000000000001um) (purcell_e1_x + -699.9999999999999um, purcell_e1_y + 8.009664216553778e-15um, purcell_e1_z + -850.0000000000001um) (purcell_e1_x + 708.9550000000002um, purcell_e1_y + -8.112130706638384e-15um, purcell_e1_z + -850.0829999999999um) (purcell_e1_x + 721.9730000000002um, purcell_e1_y + -8.261087576311379e-15um, purcell_e1_z + -850.9669999999999um) (purcell_e1_x + 733.8820000000002um, purcell_e1_y + -8.397354849389862e-15um, purcell_e1_z + -853.0229999999999um) (purcell_e1_x + 744.8430000000001um, purcell_e1_y + -8.522774748643642e-15um, purcell_e1_z + -856.2749999999999um) (purcell_e1_x + 755.0340000000001um, purcell_e1_y + -8.639384017259212e-15um, purcell_e1_z + -860.7449999999999um) (purcell_e1_x + 764.2200000000001um, purcell_e1_y + -8.744493696535304e-15um, purcell_e1_z + -866.2879999999999um) (purcell_e1_x + 772.7990000000001um, purcell_e1_y + -8.842657852697893e-15um, purcell_e1_z + -873.2019999999999um) (purcell_e1_x + 780.1090000000002um, purcell_e1_y + -8.92630163187362e-15um, purcell_e1_z + -881.0039999999999um) (purcell_e1_x + 786.5300000000001um, purcell_e1_y + -8.999773137494322e-15um, purcell_e1_z + -890.1109999999999um) (purcell_e1_x + 791.8400000000001um, purcell_e1_y + -9.060532161765608e-15um, purcell_e1_z + -900.4189999999999um) (purcell_e1_x + 795.8040000000001um, purcell_e1_y + -9.105889745986206e-15um, purcell_e1_z + -911.5749999999999um) (purcell_e1_x + 798.4290000000001um, purcell_e1_y + -9.135925986798283e-15um, purcell_e1_z + -923.6059999999999um) (purcell_e1_x + 799.7270000000001um, purcell_e1_y + -9.150778192731265e-15um, purcell_e1_z + -936.2509999999999um) (purcell_e1_x + 799.9540000000002um, purcell_e1_y + -9.153375612412918e-15um, purcell_e1_z + -1057.269um) (purcell_e1_x + 799.1340000000001um, purcell_e1_y + -9.143992862902098e-15um, purcell_e1_z + -1071.0810000000001um) (purcell_e1_x + 797.0820000000001um, purcell_e1_y + -9.120513104370142e-15um, purcell_e1_z + -1083.425um) (purcell_e1_x + 793.4510000000001um, purcell_e1_y + -9.078965831841133e-15um, purcell_e1_z + -1095.584um) (purcell_e1_x + 788.0890000000002um, purcell_e1_y + -9.017611803942329e-15um, purcell_e1_z + -1107.205um) (purcell_e1_x + 781.4940000000001um, purcell_e1_y + -8.942149324644941e-15um, purcell_e1_z + -1117.248um) (purcell_e1_x + 773.1620000000001um, purcell_e1_y + -8.846811435713047e-15um, purcell_e1_z + -1126.459um) (purcell_e1_x + 763.7120000000001um, purcell_e1_y + -8.73868096878957e-15um, purcell_e1_z + -1134.063um) (purcell_e1_x + 752.9970000000002um, purcell_e1_y + -8.616075894389038e-15um, purcell_e1_z + -1140.276um) (purcell_e1_x + 741.2990000000001um, purcell_e1_y + -8.482222962952971e-15um, purcell_e1_z + -1144.9370000000001um) (purcell_e1_x + 728.1030000000002um, purcell_e1_y + -8.33122935009348e-15um, purcell_e1_z + -1148.147um) (purcell_e1_x + 701.5080000000002um, purcell_e1_y + -8.026919321751698e-15um, purcell_e1_z + -1150.0um) (purcell_e1_x + -699.9999999999999um, purcell_e1_y + 8.009664216553783e-15um, purcell_e1_z + -1150.0um) (purcell_e1_x + -699.9999999999999um, purcell_e1_y + 8.009664216553785e-15um, purcell_e1_z + -1250.0um) (purcell_e1_x + 708.2560000000001um, purcell_e1_y + -8.104132484799274e-15um, purcell_e1_z + -1250.066um) (purcell_e1_x + 731.5080000000002um, purcell_e1_y + -8.370190645318288e-15um, purcell_e1_z + -1252.501um) (purcell_e1_x + 751.4750000000001um, purcell_e1_y + -8.598660595906758e-15um, purcell_e1_z + -1259.005um) (purcell_e1_x + 760.4000000000001um, purcell_e1_y + -8.700783814667817e-15um, purcell_e1_z + -1263.7830000000001um) (purcell_e1_x + 768.7470000000002um, purcell_e1_y + -8.796293339261496e-15um, purcell_e1_z + -1269.689um) (purcell_e1_x + 776.0030000000002um, purcell_e1_y + -8.879319230054801e-15um, purcell_e1_z + -1276.357um) (purcell_e1_x + 782.6270000000002um, purcell_e1_y + -8.955113538298304e-15um, purcell_e1_z + -1284.262um) (purcell_e1_x + 789.2550000000001um, purcell_e1_y + -9.030953616051616e-15um, purcell_e1_z + -1294.9660000000001um) (purcell_e1_x + 794.2070000000001um, purcell_e1_y + -9.087616269195008e-15um, purcell_e1_z + -1306.51um) (purcell_e1_x + 797.6580000000001um, purcell_e1_y + -9.127103913782618e-15um, purcell_e1_z + -1319.272um) (purcell_e1_x + 799.5010000000001um, purcell_e1_y + -9.148192215427058e-15um, purcell_e1_z + -1332.838um) (purcell_e1_x + 799.9760000000002um, purcell_e1_y + -9.153627344716859e-15um, purcell_e1_z + -1455.8um) (purcell_e1_x + 799.3040000000002um, purcell_e1_y + -9.145938067068968e-15um, purcell_e1_z + -1469.426um) (purcell_e1_x + 797.5910000000002um, purcell_e1_y + -9.126337274493315e-15um, purcell_e1_z + -1481.061um) (purcell_e1_x + 794.0350000000002um, purcell_e1_y + -9.085648180273222e-15um, purcell_e1_z + -1493.981um) (purcell_e1_x + 788.8530000000003um, purcell_e1_y + -9.026353780315821e-15um, purcell_e1_z + -1505.8um) (purcell_e1_x + 782.1610000000003um, purcell_e1_y + -8.949781390405567e-15um, purcell_e1_z + -1516.368um) (purcell_e1_x + 774.0020000000003um, purcell_e1_y + -8.856423032772906e-15um, purcell_e1_z + -1525.656um) (purcell_e1_x + 764.2200000000003um, purcell_e1_y + -8.744493696535294e-15um, purcell_e1_z + -1533.712um) (purcell_e1_x + 753.5060000000002um, purcell_e1_y + -8.621900064512211e-15um, purcell_e1_z + -1540.027um) (purcell_e1_x + 741.2990000000002um, purcell_e1_y + -8.482222962952966e-15um, purcell_e1_z + -1544.9370000000001um) (purcell_e1_x + 728.5350000000002um, purcell_e1_y + -8.336172457152834e-15um, purcell_e1_z + -1548.0710000000001um) (purcell_e1_x + 715.8790000000002um, purcell_e1_y + -8.191357728117542e-15um, purcell_e1_z + -1549.596um) (purcell_e1_x + 701.5080000000003um, purcell_e1_y + -8.026919321751693e-15um, purcell_e1_z + -1550.0um) (purcell_e1_x + -699.9999999999998um, purcell_e1_y + 8.009664216553788e-15um, purcell_e1_z + -1550.0um) (purcell_e1_x + -699.9999999999998um, purcell_e1_y + 8.00966421655379e-15um, purcell_e1_z + -1650.0um) (purcell_e1_x + 707.2690000000002um, purcell_e1_y + -8.092838858253929e-15um, purcell_e1_z + -1650.046um) (purcell_e1_x + 728.1030000000003um, purcell_e1_y + -8.331229350093474e-15um, purcell_e1_z + -1651.853um) (purcell_e1_x + 746.5770000000002um, purcell_e1_y + -8.54261583114578e-15um, purcell_e1_z + -1656.928um) (purcell_e1_x + 763.0770000000002um, purcell_e1_y + -8.731415059107404e-15um, purcell_e1_z + -1665.506um) (purcell_e1_x + 777.0220000000003um, purcell_e1_y + -8.890979012678608e-15um, purcell_e1_z + -1677.443um) (purcell_e1_x + 785.4140000000002um, purcell_e1_y + -8.987003444257633e-15um, purcell_e1_z + -1688.324um) (purcell_e1_x + 792.0020000000003um, purcell_e1_y + -9.062385826912857e-15um, purcell_e1_z + -1700.796um) (purcell_e1_x + 796.5290000000002um, purcell_e1_y + -9.114185469639056e-15um, purcell_e1_z + -1714.275um) (purcell_e1_x + 799.1970000000002um, purcell_e1_y + -9.144713732681578e-15um, purcell_e1_z + -1729.508um) (purcell_e1_x + 799.9920000000002um, purcell_e1_y + -9.153810422756092e-15um, purcell_e1_z + -1746.019um) (purcell_e1_x + 799.9860000000002um, purcell_e1_y + -9.153741768491377e-15um, purcell_e1_z + -1854.808um) (purcell_e1_x + 798.0710000000003um, purcell_e1_y + -9.131829615670376e-15um, purcell_e1_z + -1878.535um) (purcell_e1_x + 794.8200000000003um, purcell_e1_y + -9.09463044657321e-15um, purcell_e1_z + -1891.662um) (purcell_e1_x + 789.8380000000002um, purcell_e1_y + -9.037624522106251e-15um, purcell_e1_z + -1903.887um) (purcell_e1_x + 783.2660000000002um, purcell_e1_y + -8.962425217490262e-15um, purcell_e1_z + -1914.853um) (purcell_e1_x + 775.0720000000002um, purcell_e1_y + -8.868666376646774e-15um, purcell_e1_z + -1924.598um) (purcell_e1_x + 765.3590000000003um, purcell_e1_y + -8.757526564453365e-15um, purcell_e1_z + -1932.903um) (purcell_e1_x + 754.5240000000002um, purcell_e1_y + -8.633548404758566e-15um, purcell_e1_z + -1939.517um) (purcell_e1_x + 742.5130000000003um, purcell_e1_y + -8.496114009179955e-15um, purcell_e1_z + -1944.54um) (purcell_e1_x + 729.2970000000003um, purcell_e1_y + -8.34489154877142e-15um, purcell_e1_z + -1947.933um) (purcell_e1_x + 717.2540000000002um, purcell_e1_y + -8.207090997114338e-15um, purcell_e1_z + -1949.4940000000001um) (purcell_e1_x + 702.2010000000002um, purcell_e1_y + -8.034848889326076e-15um, purcell_e1_z + -1949.999um) (purcell_e1_x + -699.9999999999998um, purcell_e1_y + 8.009664216553794e-15um, purcell_e1_z + -1950.0um) (purcell_e1_x + -699.9999999999998um, purcell_e1_y + 8.009664216553796e-15um, purcell_e1_z + -2050.0um) (purcell_e1_x + 705.8000000000003um, purcell_e1_y + -8.076030005776613e-15um, purcell_e1_z + -2050.024um) (purcell_e1_x + 724.6160000000002um, purcell_e1_y + -8.291329779917577e-15um, purcell_e1_z + -2051.3070000000002um) (purcell_e1_x + 741.0580000000002um, purcell_e1_y + -8.479465349986973e-15um, purcell_e1_z + -2054.987um) (purcell_e1_x + 755.8000000000003um, purcell_e1_y + -8.648148878387597e-15um, purcell_e1_z + -2061.147um) (purcell_e1_x + 769.1200000000002um, purcell_e1_y + -8.800561346051162e-15um, purcell_e1_z + -2069.992um) (purcell_e1_x + 780.0080000000003um, purcell_e1_y + -8.92514595175093e-15um, purcell_e1_z + -2080.88um) (purcell_e1_x + 788.6480000000003um, purcell_e1_y + -9.024008092938108e-15um, purcell_e1_z + -2093.817um) (purcell_e1_x + 794.9370000000002um, purcell_e1_y + -9.095969204735117e-15um, purcell_e1_z + -2108.701um) (purcell_e1_x + 798.6490000000002um, purcell_e1_y + -9.138443309837755e-15um, purcell_e1_z + -2125.073um) (purcell_e1_x + 800.0000000000002um, purcell_e1_y + -9.153901961775704e-15um, purcell_e1_z + -2148.492um) (purcell_e1_x + 799.9800000000002um, purcell_e1_y + -9.153673114226659e-15um, purcell_e1_z + -2255.443um) (purcell_e1_x + 798.6490000000002um, purcell_e1_y + -9.138443309837752e-15um, purcell_e1_z + -2274.927um) (purcell_e1_x + 795.7020000000002um, purcell_e1_y + -9.104722623486062e-15um, purcell_e1_z + -2288.781um) (purcell_e1_x + 790.9950000000002um, purcell_e1_y + -9.050863352818463e-15um, purcell_e1_z + -2301.475um) (purcell_e1_x + 784.4940000000003um, purcell_e1_y + -8.976476457001584e-15um, purcell_e1_z + -2313.077um) (purcell_e1_x + 776.3460000000003um, purcell_e1_y + -8.883243965520897e-15um, purcell_e1_z + -2323.282um) (purcell_e1_x + 766.6200000000003um, purcell_e1_y + -8.77195540242061e-15um, purcell_e1_z + -2331.972um) (purcell_e1_x + 755.4170000000004um, purcell_e1_y + -8.643766447823393e-15um, purcell_e1_z + -2339.055um) (purcell_e1_x + 742.8790000000004um, purcell_e1_y + -8.500301919327462e-15um, purcell_e1_z + -2344.417um) (purcell_e1_x + 729.7350000000004um, purcell_e1_y + -8.349903310095487e-15um, purcell_e1_z + -2347.851um) (purcell_e1_x + 717.2540000000004um, purcell_e1_y + -8.207090997114333e-15um, purcell_e1_z + -2349.494um) (purcell_e1_x + 702.2010000000004um, purcell_e1_y + -8.034848889326071e-15um, purcell_e1_z + -2349.9990000000003um) (purcell_e1_x + -699.9999999999997um, purcell_e1_y + 8.009664216553799e-15um, purcell_e1_z + -2350.0um) (purcell_e1_x + -699.9999999999997um, purcell_e1_y + 8.0096642165538e-15um, purcell_e1_z + -2450.0um) (purcell_e1_x + 704.8080000000003um, purcell_e1_y + -8.064679167344006e-15um, purcell_e1_z + -2450.014um) (purcell_e1_x + 719.7150000000004um, purcell_e1_y + -8.235250688024244e-15um, purcell_e1_z + -2450.724um) (purcell_e1_x + 732.5190000000003um, purcell_e1_y + -8.381758888922465e-15um, purcell_e1_z + -2452.716um) (purcell_e1_x + 744.8430000000003um, purcell_e1_y + -8.52277474864362e-15um, purcell_e1_z + -2456.275um) (purcell_e1_x + 756.1830000000003um, purcell_e1_y + -8.652531308951792e-15um, purcell_e1_z + -2461.352um) (purcell_e1_x + 771.0950000000004um, purcell_e1_y + -8.82316004151929e-15um, purcell_e1_z + -2471.664um) (purcell_e1_x + 782.9030000000004um, purcell_e1_y + -8.958271634475101e-15um, purcell_e1_z + -2484.641um) (purcell_e1_x + 791.7310000000003um, purcell_e1_y + -9.059284942623294e-15um, purcell_e1_z + -2500.167um) (purcell_e1_x + 797.4290000000003um, purcell_e1_y + -9.124483609346041e-15um, purcell_e1_z + -2518.157um) (purcell_e1_x + 799.2470000000004um, purcell_e1_y + -9.145285851554178e-15um, purcell_e1_z + -2529.995um) (purcell_e1_x + 799.9640000000004um, purcell_e1_y + -9.15349003618742e-15um, purcell_e1_z + -2543.326um) (purcell_e1_x + 799.5960000000003um, purcell_e1_y + -9.149279241285e-15um, purcell_e1_z + -2665.879um) (purcell_e1_x + 797.7020000000003um, purcell_e1_y + -9.127607378390496e-15um, purcell_e1_z + -2680.506um) (purcell_e1_x + 794.0350000000003um, purcell_e1_y + -9.085648180273206e-15um, purcell_e1_z + -2693.981um) (purcell_e1_x + 788.3710000000003um, purcell_e1_y + -9.020838554383834e-15um, purcell_e1_z + -2706.694um) (purcell_e1_x + 781.1050000000004um, purcell_e1_y + -8.937698239816006e-15um, purcell_e1_z + -2717.7490000000003um) (purcell_e1_x + 772.0720000000003um, purcell_e1_y + -8.834339244290105e-15um, purcell_e1_z + -2727.466um) (purcell_e1_x + 761.9310000000004um, purcell_e1_y + -8.718302094547145e-15um, purcell_e1_z + -2735.25um) (purcell_e1_x + 749.9590000000004um, purcell_e1_y + -8.581313951689172e-15um, purcell_e1_z + -2741.676um) (purcell_e1_x + 736.8920000000004um, purcell_e1_y + -8.431796405521017e-15um, purcell_e1_z + -2746.226um) (purcell_e1_x + 721.0810000000004um, purcell_e1_y + -8.250880975623971e-15um, purcell_e1_z + -2749.134um) (purcell_e1_x + 702.5870000000003um, purcell_e1_y + -8.03926564702262e-15um, purcell_e1_z + -2749.998um) (purcell_e1_x + -699.9999999999997um, purcell_e1_y + 8.009664216553805e-15um, purcell_e1_z + -2750.0um) (purcell_e1_x + -699.9999999999997um, purcell_e1_y + 8.009664216553807e-15um, purcell_e1_z + -2850.0um) (purcell_e1_x + 702.2010000000004um, purcell_e1_y + -8.034848889326063e-15um, purcell_e1_z + -2850.001um) (purcell_e1_x + 717.6260000000003um, purcell_e1_y + -8.211347561526551e-15um, purcell_e1_z + -2850.536um) (purcell_e1_x + 730.5060000000003um, purcell_e1_y + -8.35872538311114e-15um, purcell_e1_z + -2852.2980000000002um) (purcell_e1_x + 744.5960000000003um, purcell_e1_y + -8.519948481412916e-15um, purcell_e1_z + -2856.185um) (purcell_e1_x + 757.2050000000004um, purcell_e1_y + -8.664225418707954e-15um, purcell_e1_z + -2861.911um) (purcell_e1_x + 768.4980000000004um, purcell_e1_y + -8.79344418727587e-15um, purcell_e1_z + -2869.4880000000003um) (purcell_e1_x + 778.3360000000004um, purcell_e1_y + -8.906014296650807e-15um, purcell_e1_z + -2878.905um) (purcell_e1_x + 786.5300000000003um, purcell_e1_y + -8.999773137494295e-15um, purcell_e1_z + -2890.111um) (purcell_e1_x + 792.6770000000004um, purcell_e1_y + -9.07010943169309e-15um, purcell_e1_z + -2902.426um) (purcell_e1_x + 796.9770000000003um, purcell_e1_y + -9.119311654737634e-15um, purcell_e1_z + -2916.118um) (purcell_e1_x + 799.3490000000004um, purcell_e1_y + -9.146452974054299e-15um, purcell_e1_z + -2931.052um) (purcell_e1_x + 799.9760000000003um, purcell_e1_y + -9.153627344716838e-15um, purcell_e1_z + -3055.8um) (purcell_e1_x + 799.3040000000003um, purcell_e1_y + -9.145938067068948e-15um, purcell_e1_z + -3069.426um) (purcell_e1_x + 797.5910000000003um, purcell_e1_y + -9.126337274493293e-15um, purcell_e1_z + -3081.061um) (purcell_e1_x + 792.0020000000004um, purcell_e1_y + -9.062385826912838e-15um, purcell_e1_z + -3099.204um) (purcell_e1_x + 783.2660000000003um, purcell_e1_y + -8.962425217490246e-15um, purcell_e1_z + -3114.853um) (purcell_e1_x + 771.7060000000004um, purcell_e1_y + -8.830151334142588e-15um, purcell_e1_z + -3127.795um) (purcell_e1_x + 757.2050000000004um, purcell_e1_y + -8.66422541870795e-15um, purcell_e1_z + -3138.089um) (purcell_e1_x + 746.2040000000004um, purcell_e1_y + -8.538347824356082e-15um, purcell_e1_z + -3143.216um) (purcell_e1_x + 734.3400000000004um, purcell_e1_y + -8.402595458262948e-15um, purcell_e1_z + -3146.869um) (purcell_e1_x + 721.5750000000004um, purcell_e1_y + -8.256533510085364e-15um, purcell_e1_z + -3149.079um) (purcell_e1_x + 707.2690000000003um, purcell_e1_y + -8.092838858253909e-15um, purcell_e1_z + -3149.954um) (purcell_e1_x + 50.000000000000384um, purcell_e1_y + -5.721188726109406e-16um, purcell_e1_z + -3150.0um) (purcell_e1_x + 50.00000000000039um, purcell_e1_y + -5.721188726109399e-16um, purcell_e1_z + -3200.0um) (purcell_e1_x + -49.99999999999961um, purcell_e1_y + 5.721188726110269e-16um, purcell_e1_z + -3200.0um) (purcell_e1_x + -49.55699999999962um, purcell_e1_y + 5.670498993996927e-16um, purcell_e1_z + -3133.5750000000003um) (purcell_e1_x + -47.283999999999615um, purcell_e1_y + 5.410413754507971e-16um, purcell_e1_z + -3117.481um) (purcell_e1_x + -42.82699999999962um, purcell_e1_y + 4.900426991462539e-16um, purcell_e1_z + -3102.8um) (purcell_e1_x + -34.49399999999962um, purcell_e1_y + 3.9469336783690715e-16um, purcell_e1_z + -3086.9230000000002um) (purcell_e1_x + -23.161999999999622um, purcell_e1_y + 2.650283465483537e-16um, purcell_e1_z + -3073.541um) (purcell_e1_x + -9.121999999999625um, purcell_e1_y + 1.0437736711918945e-16um, purcell_e1_z + -3063.011um) (purcell_e1_x + 7.730000000000374um, purcell_e1_y + -8.844957770561649e-17um, purcell_e1_z + -3055.379um) (purcell_e1_x + 25.073000000000373um, purcell_e1_y + -2.8689472985946226e-16um, purcell_e1_z + -3051.351um) (purcell_e1_x + 45.19200000000038um, purcell_e1_y + -5.171039218206696e-16um, purcell_e1_z + -3050.014um) (purcell_e1_x + 700.0000000000003um, purcell_e1_y + -8.009664216553726e-15um, purcell_e1_z + -3050.0um) (purcell_e1_x + 700.0000000000003um, purcell_e1_y + -8.009664216553728e-15um, purcell_e1_z + -2950.0um) (purcell_e1_x + -709.4269999999997um, purcell_e1_y + 8.117531508795882e-15um, purcell_e1_z + -2949.904um) (purcell_e1_x + -722.5749999999997um, purcell_e1_y + 8.267975887537666e-15um, purcell_e1_z + -2948.9610000000002um) (purcell_e1_x + -734.5699999999997um, purcell_e1_y + 8.405227205077041e-15um, purcell_e1_z + -2946.814um) (purcell_e1_x + -746.2039999999997um, purcell_e1_y + 8.538347824356164e-15um, purcell_e1_z + -2943.216um) (purcell_e1_x + -756.4379999999996um, purcell_e1_y + 8.65544911520218e-15um, purcell_e1_z + -2938.51um) (purcell_e1_x + -766.2419999999996um, purcell_e1_y + 8.76763018374374e-15um, purcell_e1_z + -2932.255um) (purcell_e1_x + -774.5979999999997um, purcell_e1_y + 8.86324268973449e-15um, purcell_e1_z + -2925.072um) (purcell_e1_x + -781.9719999999996um, purcell_e1_y + 8.947618781067157e-15um, purcell_e1_z + -2916.62um) (purcell_e1_x + -788.0889999999997um, purcell_e1_y + 9.017611803942384e-15um, purcell_e1_z + -2907.205um) (purcell_e1_x + -792.8269999999997um, purcell_e1_y + 9.071825788311e-15um, purcell_e1_z + -2897.2000000000003um) (purcell_e1_x + -796.4099999999996um, purcell_e1_y + 9.112823826722303e-15um, purcell_e1_z + -2886.1910000000003um) (purcell_e1_x + -798.6929999999996um, purcell_e1_y + 9.138946774445722e-15um, purcell_e1_z + -2874.616um) (purcell_e1_x + -799.8069999999997um, purcell_e1_y + 9.151693582927495e-15um, purcell_e1_z + -2862.123um) (purcell_e1_x + -799.9539999999997um, purcell_e1_y + 9.15337561241297e-15um, purcell_e1_z + -2742.731um) (purcell_e1_x + -799.0789999999997um, purcell_e1_y + 9.143363532142278e-15um, purcell_e1_z + -2728.425um) (purcell_e1_x + -796.9769999999996um, purcell_e1_y + 9.11931165473771e-15um, purcell_e1_z + -2716.118um) (purcell_e1_x + -793.1199999999997um, purcell_e1_y + 9.075178404904498e-15um, purcell_e1_z + -2703.547um) (purcell_e1_x + -787.7299999999997um, purcell_e1_y + 9.013503990437035e-15um, purcell_e1_z + -2692.156um) (purcell_e1_x + -780.9089999999997um, purcell_e1_y + 8.935455533835444e-15um, purcell_e1_z + -2682.001um) (purcell_e1_x + -772.7989999999996um, purcell_e1_y + 8.842657852697942e-15um, purcell_e1_z + -2673.202um) (purcell_e1_x + -763.0769999999997um, purcell_e1_y + 8.731415059107463e-15um, purcell_e1_z + -2665.506um) (purcell_e1_x + -752.4889999999997um, purcell_e1_y + 8.610263166643361e-15um, purcell_e1_z + -2659.48um) (purcell_e1_x + -740.6959999999997um, purcell_e1_y + 8.475323209349335e-15um, purcell_e1_z + -2654.873um) (purcell_e1_x + -728.1029999999997um, purcell_e1_y + 8.331229350093532e-15um, purcell_e1_z + -2651.853um) (purcell_e1_x + -701.5079999999997um, purcell_e1_y + 8.02691932175175e-15um, purcell_e1_z + -2650.0um) (purcell_e1_x + 700.0000000000003um, purcell_e1_y + -8.009664216553731e-15um, purcell_e1_z + -2650.0um) (purcell_e1_x + 700.0000000000003um, purcell_e1_y + -8.009664216553733e-15um, purcell_e1_z + -2550.0um) (purcell_e1_x + -708.2559999999996um, purcell_e1_y + 8.104132484799326e-15um, purcell_e1_z + -2549.934um) (purcell_e1_x + -731.0609999999997um, purcell_e1_y + 8.365075902597197e-15um, purcell_e1_z + -2547.591um) (purcell_e1_x + -750.5899999999997um, purcell_e1_y + 8.588534091861595e-15um, purcell_e1_z + -2541.397um) (purcell_e1_x + -759.8889999999997um, purcell_e1_y + 8.694936759789786e-15um, purcell_e1_z + -2536.53um) (purcell_e1_x + -767.9989999999997um, purcell_e1_y + 8.787734440927286e-15um, purcell_e1_z + -2530.909um) (purcell_e1_x + -775.4239999999996um, purcell_e1_y + 8.872694093510018e-15um, purcell_e1_z + -2524.241um) (purcell_e1_x + -781.7819999999997um, purcell_e1_y + 8.94544472935123e-15um, purcell_e1_z + -2516.871um) (purcell_e1_x + -788.6479999999997um, purcell_e1_y + 9.024008092938171e-15um, purcell_e1_z + -2506.183um) (purcell_e1_x + -794.0349999999996um, purcell_e1_y + 9.085648180273276e-15um, purcell_e1_z + -2493.981um) (purcell_e1_x + -797.5909999999997um, purcell_e1_y + 9.126337274493369e-15um, purcell_e1_z + -2481.061um) (purcell_e1_x + -799.4939999999997um, purcell_e1_y + 9.148112118784944e-15um, purcell_e1_z + -2467.254um) (purcell_e1_x + -799.9759999999997um, purcell_e1_y + 9.153627344716911e-15um, purcell_e1_z + -2344.2000000000003um) (purcell_e1_x + -797.6579999999998um, purcell_e1_y + 9.127103913782667e-15um, purcell_e1_z + -2319.272um) (purcell_e1_x + -794.2069999999998um, purcell_e1_y + 9.087616269195056e-15um, purcell_e1_z + -2306.51um) (purcell_e1_x + -789.0549999999998um, purcell_e1_y + 9.028665140561222e-15um, purcell_e1_z + -2294.583um) (purcell_e1_x + -782.2549999999998um, purcell_e1_y + 8.950856973886127e-15um, purcell_e1_z + -2283.7580000000003um) (purcell_e1_x + -774.2409999999998um, purcell_e1_y + 8.859157760984039e-15um, purcell_e1_z + -2274.576um) (purcell_e1_x + -764.8529999999998um, purcell_e1_y + 8.7517367214626e-15um, purcell_e1_z + -2266.734um) (purcell_e1_x + -753.8869999999998um, purcell_e1_y + 8.626259610321559e-15um, purcell_e1_z + -2260.1620000000003um) (purcell_e1_x + -741.9049999999997um, purcell_e1_y + 8.489157043689061e-15um, purcell_e1_z + -2255.259um) (purcell_e1_x + -728.9689999999998um, purcell_e1_y + 8.341138448967148e-15um, purcell_e1_z + -2252.007um) (purcell_e1_x + -716.4249999999998um, purcell_e1_y + 8.197605266206505e-15um, purcell_e1_z + -2250.443um) (purcell_e1_x + -701.5079999999998um, purcell_e1_y + 8.026919321751744e-15um, purcell_e1_z + -2250.0um) (purcell_e1_x + 700.0000000000002um, purcell_e1_y + -8.009664216553737e-15um, purcell_e1_z + -2250.0um) (purcell_e1_x + 700.0000000000002um, purcell_e1_y + -8.009664216553737e-15um, purcell_e1_z + -2150.0um) (purcell_e1_x + -705.7999999999998um, purcell_e1_y + 8.076030005776671e-15um, purcell_e1_z + -2149.976um) (purcell_e1_x + -724.3059999999998um, purcell_e1_y + 8.287782642907448e-15um, purcell_e1_z + -2148.736um) (purcell_e1_x + -740.3349999999998um, purcell_e1_y + 8.471192511089075e-15um, purcell_e1_z + -2145.239um) (purcell_e1_x + -755.0339999999998um, purcell_e1_y + 8.639384017259252e-15um, purcell_e1_z + -2139.255um) (purcell_e1_x + -768.1239999999998um, purcell_e1_y + 8.789164738108809e-15um, purcell_e1_z + -2130.81um) (purcell_e1_x + -779.2869999999998um, purcell_e1_y + 8.916895997607936e-15um, purcell_e1_z + -2119.987um) (purcell_e1_x + -788.1599999999997um, purcell_e1_y + 9.01842421274148e-15um, purcell_e1_z + -2107.077um) (purcell_e1_x + -794.6209999999998um, purcell_e1_y + 9.092353413460272e-15um, purcell_e1_z + -2092.27um) (purcell_e1_x + -798.5419999999998um, purcell_e1_y + 9.137218975450426e-15um, purcell_e1_z + -2075.657um) (purcell_e1_x + -799.9999999999998um, purcell_e1_y + 9.153901961775763e-15um, purcell_e1_z + -2051.5080000000003um)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, closed, covered)
boundaries and excitations:
  transmon_perfect_e: Perfect E Objects=[transmon_0, transmon_1]
  junction_inductance_boundary: Lumped RLC Objects=transmon_junction CurrentLine{(0, 0.1905, -3.401498) -> (0, 0.1905, -3.398498)} RLC_Type=Parallel Inductance=junction_inductance
  readout_perfect_e: Perfect E Objects=readout
  purcell_perfect_e: Perfect E Objects=purcell
mesh:
  chip_base_mesh: LengthBased RefineInside Objects=chip_base MaxLength=1mm
  transmon_mesh: LengthBased Objects=[transmon_0, transmon_1] MaxLength=50um
  junction_mesh: LengthBased Objects=transmon_junction MaxLength=5um
  readout_mesh: LengthBased Objects=readout MaxLength=50um
  purcell_mesh: LengthBased Objects=purcell MaxLength=50um
  initial mesh: GlobalCurvilinear{Apply} DynamicSurfaceResolution
setups:
  Setup1: HfssEigen MinimumFrequency=2GHz NumModes=3 MaxDeltaFreq=0.2 ConvergeOnRealFreq=true MaximumPasses=3 MinimumPasses=1 MinimumConvergedPasses=1 PercentRefinement=30 BasisOrder=-1
source amplitudes:
  #-10:1: 1 0deg
  #-10:2, #-10:3: 0 0deg
field plots:
  Mesh1: MeshPlots in chip_base on Setup1 : LastAdaptive at Phase=0deg
