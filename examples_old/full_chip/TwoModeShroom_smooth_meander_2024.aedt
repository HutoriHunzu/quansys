# Ansys Electronics Desktop project, version 2024.2
project variables:
  $TransmonLead_length = 70um
  $JJ_length = 10um
  $TransmonAntena_depth = 665um
  $TransmonAntena_length = 1.8mm
  $ChipBase_width = 1.7mm
  $JJ_width = 4um
  $TransmonAntena_radius = 0.25mm
  $TransmonLead_width = 20um
  $TransmonPad_width = 1000um
  $TransmonAntena_width = 0.1mm
  $TransmonPad_length = 400um
  $ChipBase_length = (28 - 4.75) mm
  $ChipBase_thickness = 0.3mm
  $ChipBase_end = 5.25mm
  $ChipBase_x = -2.905mm
  $ChipBase_y = 19.94mm
  $ChipBase_z = 33.25mm
materials:
  vacuum: permittivity=1
  perfect conductor: conductivity=1e+30
  sapphire: permittivity=10
surface materials:
  Steel-oxidised-surface

design NoCavity (HFSS, Eigenmode, model units mm)
variables:
  transmon_wg_radius = 2mm
  sapphire_house_length = 22mm
  transmon_pin_location = 8.95mm
  readout_pin_location = 15mm
  spacer = 0.5mm
  sapphire_house_pins_diameter = 0.5mm
  sapphire_house_pins_waveguide_diameter = 1.15mm
  sapphire_house_pins_waveguide_length = 6mm
  transmon_pin_length = 4mm
  readout_pin_length = 6.7mm
  Lj = 9.75nH
  ChipBase_x = -$ChipBase_width / 2
  ChipBase_y = -$ChipBase_thickness / 2
  ChipBase_z = sapphire_house_length + spacer
  ChipBase_length = (28 - 4.75) mm
  ChipBase_end = ChipBase_z - ChipBase_length
  readout_transmon_gap = 200um
  transmon_end = -ChipBase_end - 3.015mm
  purcell_readout_gap = 2mm
  readout_length = 5.2mm
  purcell_length = 5.4mm
  purcell_width = 600um
  purcell_start_pos_z = readout_start_pos_z + readout_length + purcell_readout_gap + readout_thickness / 2 + purcell_thickness / 2
  purcell_start_pos_y = ChipBase_y
  purcell_thickness = 80um
  purcell_start_pos_x = ChipBase_x + $ChipBase_width/2
  purcell_fillet = 100um
  readout_thickness = 80um
  readout_fillet = 100um
  readout_start_pos_z = -transmon_end + readout_transmon_gap + readout_thickness / 2
  readout_start_pos_x = ChipBase_x + $ChipBase_width/2
  readout_width = 600um
  readout_start_pos_y = ChipBase_y
geometry:
  saph_house_back_cylin1 = cylinder(axis=Z, base_centre=(0mm, 2.5mm, -sapphire_house_length), radius=3.5mm, height=-spacer)
  saph_house_back_cylin2 = cylinder(axis=Z, base_centre=(0mm, -2.5mm, -sapphire_house_length), radius=3.5mm, height=-spacer)
  sapphire_house_back = box(corner=(-3.5mm, -2.5mm, -sapphire_house_length), size=(7mm, 5mm, -spacer))
  sapphire_house_wg = cylinder(axis=Z, base_centre=(0mm, 0mm, -sapphire_house_length), radius=transmon_wg_radius, height=sapphire_house_length)
  transmon_pin_wg = cylinder(axis=Y, base_centre=(0mm, 0mm, -transmon_pin_location), radius=sapphire_house_pins_waveguide_diameter/2, height=transmon_wg_radius + sapphire_house_pins_waveguide_length)
  transmon_pin [perfect conductor] = cylinder(axis=Y, base_centre=(0mm, transmon_wg_radius + sapphire_house_pins_waveguide_length, -transmon_pin_location), radius=sapphire_house_pins_diameter/2, height=-transmon_pin_length)
  readout_pin_wg = cylinder(axis=Y, base_centre=(0mm, 0mm, -readout_pin_location), radius=sapphire_house_pins_waveguide_diameter/2, height=-transmon_wg_radius - sapphire_house_pins_waveguide_length)
  readout_pin [perfect conductor] = cylinder(axis=Y, base_centre=(0mm, -transmon_wg_radius - sapphire_house_pins_waveguide_length, -readout_pin_location), radius=sapphire_house_pins_diameter/2, height=readout_pin_length)
  JJ = rectangle(corner=(ChipBase_x + $ChipBase_width/2 - $JJ_width/2, -ChipBase_y, -ChipBase_end-$TransmonAntena_depth-$TransmonAntena_length-$TransmonLead_length), z_size=-$JJ_length, x_size=$JJ_width)
  line_jj1 = polyline((ChipBase_x + $ChipBase_width/2, ChipBase_y, ChipBase_end+$TransmonAntena_depth+$TransmonAntena_length+$TransmonLead_length + $JJ_length) (ChipBase_x + $ChipBase_width/2, ChipBase_y, ChipBase_end+$TransmonAntena_depth+$TransmonAntena_length+$TransmonLead_length))
  Transmon1 = rectangle(corner=(ChipBase_x + $ChipBase_width/2 - $TransmonPad_width/2, ChipBase_y, ChipBase_end + $TransmonAntena_depth + $TransmonAntena_length), z_size=-$TransmonPad_length, x_size=$TransmonPad_width)
  Rectangle15 = rectangle(corner=(ChipBase_x + $ChipBase_width/2 - $TransmonAntena_width/2, ChipBase_y, ChipBase_end + $TransmonAntena_depth + $TransmonAntena_length), z_size=-$TransmonAntena_length, x_size=$TransmonAntena_width)
  Circle2 = circle(normal=Y, centre=(ChipBase_x + $ChipBase_width/2, ChipBase_y, ChipBase_end+$TransmonAntena_depth), radius=$TransmonAntena_radius)
  Rectangle16 = rectangle(corner=(ChipBase_x + $ChipBase_width/2 - $TransmonLead_width/2, ChipBase_y, ChipBase_end + $TransmonAntena_depth + $TransmonAntena_length + $TransmonLead_length), z_size=-$TransmonLead_length, x_size=$TransmonLead_width)
  Transmon1.unite(Rectangle15, Circle2, Rectangle16)
  Transmon2 = rectangle(corner=(ChipBase_x + $ChipBase_width/2 - $TransmonPad_width/2, ChipBase_y, ChipBase_end + $TransmonAntena_depth + $TransmonAntena_length + $TransmonPad_length + $TransmonLead_length + $JJ_length + $TransmonLead_length), z_size=-$TransmonPad_length, x_size=$TransmonPad_width)
  Rectangle17 = rectangle(corner=(ChipBase_x + $ChipBase_width/2 - $TransmonLead_width/2, ChipBase_y, ChipBase_end + $TransmonAntena_depth + $TransmonAntena_length + $TransmonLead_length + $JJ_length + $TransmonLead_length), z_size=-$TransmonLead_length, x_size=$TransmonLead_width)
  Transmon2.unite(Rectangle17)
  ChipBase [sapphire] = box(corner=(ChipBase_x, ChipBase_y, ChipBase_z), size=($ChipBase_width, $ChipBase_thickness, -ChipBase_length))
  [line_jj1, Transmon1, Transmon2, ChipBase].rotate(axis=Z, angle=180deg)
  [line_jj1, Transmon1, Transmon2, ChipBase].rotate(axis=Y, angle=180deg)
  readout_pin_wg.unite(saph_house_back_cylin1, saph_house_back_cylin2, sapphire_house_back, sapphire_house_wg, transmon_pin_wg)
  sapphire_house_back1 [vacuum] = box(corner=(-3.5mm, -2.5mm, 0), size=(7mm, 5mm, 2mm))
  sapphire_house_back1.unite(readout_pin_wg)
  purcell_resonator = polyline((purcell_start_pos_z, purcell_start_pos_x + 0.5*purcell_thickness, purcell_start_pos_y) (purcell_start_pos_z, purcell_start_pos_x - 0.5*purcell_thickness, purcell_start_pos_y))
  cable_0_path = polyline(z=purcell_start_pos_y, xy: (purcell_start_pos_z, purcell_start_pos_x) (-17.6*purcell_fillet + purcell_length/2 + purcell_start_pos_z, purcell_start_pos_x) (-17.6*purcell_fillet + purcell_length/2 + purcell_start_pos_z, purcell_start_pos_x + purcell_width) (-15.4*purcell_fillet + purcell_length/2 + purcell_start_pos_z, purcell_start_pos_x + purcell_width) (-15.4*purcell_fillet + purcell_length/2 + purcell_start_pos_z, purcell_start_pos_x - purcell_width) (-13.2*purcell_fillet + purcell_length/2 + purcell_start_pos_z, purcell_start_pos_x - purcell_width) (-13.2*purcell_fillet + purcell_length/2 + purcell_start_pos_z, purcell_start_pos_x + purcell_width) (-11.0*purcell_fillet + purcell_length/2 + purcell_start_pos_z, purcell_start_pos_x + purcell_width) (-11.0*purcell_fillet + purcell_length/2 + purcell_start_pos_z, purcell_start_pos_x - purcell_width) (-8.8*purcell_fillet + purcell_length/2 + purcell_start_pos_z, purcell_start_pos_x - purcell_width) (-8.8*purcell_fillet + purcell_length/2 + purcell_start_pos_z, purcell_start_pos_x + purcell_width) (-6.6*purcell_fillet + purcell_length/2 + purcell_start_pos_z, purcell_start_pos_x + purcell_width) (-6.6*purcell_fillet + purcell_length/2 + purcell_start_pos_z, purcell_start_pos_x - purcell_width) (-4.4*purcell_fillet + purcell_length/2 + purcell_start_pos_z, purcell_start_pos_x - purcell_width) (-4.4*purcell_fillet + purcell_length/2 + purcell_start_pos_z, purcell_start_pos_x + purcell_width) (-2.2*purcell_fillet + purcell_length/2 + purcell_start_pos_z, purcell_start_pos_x + purcell_width) (-2.2*purcell_fillet + purcell_length/2 + purcell_start_pos_z, purcell_start_pos_x - purcell_width) (purcell_length/2 + purcell_start_pos_z, purcell_start_pos_x - purcell_width) (purcell_length/2 + purcell_start_pos_z, purcell_start_pos_x + purcell_width) (2.2*purcell_fillet + purcell_length/2 + purcell_start_pos_z, purcell_start_pos_x + purcell_width) (2.2*purcell_fillet + purcell_length/2 + purcell_start_pos_z, purcell_start_pos_x - purcell_width) (4.4*purcell_fillet + purcell_length/2 + purcell_start_pos_z, purcell_start_pos_x - purcell_width) (4.4*purcell_fillet + purcell_length/2 + purcell_start_pos_z, purcell_start_pos_x + purcell_width) (6.6*purcell_fillet + purcell_length/2 + purcell_start_pos_z, purcell_start_pos_x + purcell_width) (6.6*purcell_fillet + purcell_length/2 + purcell_start_pos_z, purcell_start_pos_x - purcell_width) (8.8*purcell_fillet + purcell_length/2 + purcell_start_pos_z, purcell_start_pos_x - purcell_width) (8.8*purcell_fillet + purcell_length/2 + purcell_start_pos_z, purcell_start_pos_x + purcell_width) (11.0*purcell_fillet + purcell_length/2 + purcell_start_pos_z, purcell_start_pos_x + purcell_width) (11.0*purcell_fillet + purcell_length/2 + purcell_start_pos_z, purcell_start_pos_x - purcell_width) (13.2*purcell_fillet + purcell_length/2 + purcell_start_pos_z, purcell_start_pos_x - purcell_width) (13.2*purcell_fillet + purcell_length/2 + purcell_start_pos_z, purcell_start_pos_x + purcell_width) (15.4*purcell_fillet + purcell_length/2 + purcell_start_pos_z, purcell_start_pos_x + purcell_width) (15.4*purcell_fillet + purcell_length/2 + purcell_start_pos_z, purcell_start_pos_x - purcell_width) (17.6*purcell_fillet + purcell_length/2 + purcell_start_pos_z, purcell_start_pos_x - purcell_width) (17.6*purcell_fillet + purcell_length/2 + purcell_start_pos_z, purcell_start_pos_x) (purcell_length + purcell_start_pos_z, purcell_start_pos_x))
  cable_0_path.fillet(Vertices=cable_0_path.vertex(at (10.725, 0, -0.15), at (10.725, 0.6, -0.15), at (10.945, 0.6, -0.15), at (10.945, -0.6, -0.15), at (11.165, -0.6, -0.15), at (11.165, 0.6, -0.15), at (11.385, 0.6, -0.15), at (11.385, -0.6, -0.15), at (11.605, -0.6, -0.15), at (11.605, 0.6, -0.15), at (11.825, 0.6, -0.15), at (11.825, -0.6, -0.15)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) Radius=purcell_fillet Setback=0mm)
  purcell_resonator.sweep_along_path(cable_0_path)
  purcell_resonator.rotate(axis=X, angle=90deg)
  purcell_resonator.rotate(axis=Y, angle=90deg)
  Circle3 = circle(normal=Y, centre=(purcell_start_pos_x, -purcell_start_pos_y, -purcell_start_pos_z), radius=purcell_thickness / 2)
  Circle4 = circle(normal=Y, centre=(purcell_start_pos_x, -purcell_start_pos_y, -purcell_start_pos_z - purcell_length), radius=purcell_thickness / 2)
  readout_resonator = polyline((readout_start_pos_z, readout_start_pos_x + 0.5*readout_thickness, readout_start_pos_y) (readout_start_pos_z, readout_start_pos_x - 0.5*readout_thickness, readout_start_pos_y))
  cable_0_path1 = polyline(z=readout_start_pos_y, xy: (readout_start_pos_z, readout_start_pos_x) (-17.6*readout_fillet + readout_length/2 + readout_start_pos_z, readout_start_pos_x) (-17.6*readout_fillet + readout_length/2 + readout_start_pos_z, readout_start_pos_x + readout_width) (-15.4*readout_fillet + readout_length/2 + readout_start_pos_z, readout_start_pos_x + readout_width) (-15.4*readout_fillet + readout_length/2 + readout_start_pos_z, readout_start_pos_x - readout_width) (-13.2*readout_fillet + readout_length/2 + readout_start_pos_z, readout_start_pos_x - readout_width) (-13.2*readout_fillet + readout_length/2 + readout_start_pos_z, readout_start_pos_x + readout_width) (-11.0*readout_fillet + readout_length/2 + readout_start_pos_z, readout_start_pos_x + readout_width) (-11.0*readout_fillet + readout_length/2 + readout_start_pos_z, readout_start_pos_x - readout_width) (-8.8*readout_fillet + readout_length/2 + readout_start_pos_z, readout_start_pos_x - readout_width) (-8.8*readout_fillet + readout_length/2 + readout_start_pos_z, readout_start_pos_x + readout_width) (-6.6*readout_fillet + readout_length/2 + readout_start_pos_z, readout_start_pos_x + readout_width) (-6.6*readout_fillet + readout_length/2 + readout_start_pos_z, readout_start_pos_x - readout_width) (-4.4*readout_fillet + readout_length/2 + readout_start_pos_z, readout_start_pos_x - readout_width) (-4.4*readout_fillet + readout_length/2 + readout_start_pos_z, readout_start_pos_x + readout_width) (-2.2*readout_fillet + readout_length/2 + readout_start_pos_z, readout_start_pos_x + readout_width) (-2.2*readout_fillet + readout_length/2 + readout_start_pos_z, readout_start_pos_x - readout_width) (readout_length/2 + readout_start_pos_z, readout_start_pos_x - readout_width) (readout_length/2 + readout_start_pos_z, readout_start_pos_x + readout_width) (2.2*readout_fillet + readout_length/2 + readout_start_pos_z, readout_start_pos_x + readout_width) (2.2*readout_fillet + readout_length/2 + readout_start_pos_z, readout_start_pos_x - readout_width) (4.4*readout_fillet + readout_length/2 + readout_start_pos_z, readout_start_pos_x - readout_width) (4.4*readout_fillet + readout_length/2 + readout_start_pos_z, readout_start_pos_x + readout_width) (6.6*readout_fillet + readout_length/2 + readout_start_pos_z, readout_start_pos_x + readout_width) (6.6*readout_fillet + readout_length/2 + readout_start_pos_z, readout_start_pos_x - readout_width) (8.8*readout_fillet + readout_length/2 + readout_start_pos_z, readout_start_pos_x - readout_width) (8.8*readout_fillet + readout_length/2 + readout_start_pos_z, readout_start_pos_x + readout_width) (11.0*readout_fillet + readout_length/2 + readout_start_pos_z, readout_start_pos_x + readout_width) (11.0*readout_fillet + readout_length/2 + readout_start_pos_z, readout_start_pos_x - readout_width) (13.2*readout_fillet + readout_length/2 + readout_start_pos_z, readout_start_pos_x - readout_width) (13.2*readout_fillet + readout_length/2 + readout_start_pos_z, readout_start_pos_x + readout_width) (15.4*readout_fillet + readout_length/2 + readout_start_pos_z, readout_start_pos_x + readout_width) (15.4*readout_fillet + readout_length/2 + readout_start_pos_z, readout_start_pos_x - readout_width) (17.6*readout_fillet + readout_length/2 + readout_start_pos_z, readout_start_pos_x - readout_width) (17.6*readout_fillet + readout_length/2 + readout_start_pos_z, readout_start_pos_x) (readout_length + readout_start_pos_z, readout_start_pos_x))
  cable_0_path1.fillet(Vertices=cable_0_path1.vertex(at (3.345, 0, -0.15), at (3.345, 0.6, -0.15), at (3.565, 0.6, -0.15), at (3.565, -0.6, -0.15), at (3.785, -0.6, -0.15), at (3.785, 0.6, -0.15), at (4.005, 0.6, -0.15), at (4.005, -0.6, -0.15), at (4.225, -0.6, -0.15), at (4.225, 0.6, -0.15), at (4.445, 0.6, -0.15), at (4.445, -0.6, -0.15)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) Radius=readout_fillet Setback=0mm)
  readout_resonator.sweep_along_path(cable_0_path1)
  readout_resonator.rotate(axis=X, angle=90deg)
  readout_resonator.rotate(axis=Y, angle=90deg)
  Circle5 = circle(normal=Y, centre=(readout_start_pos_x, -readout_start_pos_y, -readout_start_pos_z), radius=purcell_thickness / 2)
  Circle6 = circle(normal=Y, centre=(readout_start_pos_x, -readout_start_pos_y, -readout_start_pos_z - readout_length), radius=purcell_thickness / 2)
  purcell_resonator.unite(Circle3, Circle4)
  readout_resonator.unite(Circle5, Circle6)
  group TransmonChip = JJ, line_jj1, Transmon1, Transmon2, ChipBase
boundaries and excitations:
  PerfectE: Perfect E Objects=[purcell_resonator, readout_resonator, Transmon1, Transmon2]
  TransmonDriveImp: Lumped RLC Faces=sapphire_house_back1.face(at (0, 8, -8.95)) CurrentLine{(0, 8, -8.95) -> (-500mm, 8000mm, -8700mm)} RLC_Type=Parallel Resistance=50ohm
  ReadoutDriveImp: Lumped RLC Faces=sapphire_house_back1.face(at (0, -8, -15)) CurrentLine{(0, -8, -15) -> (-0.575, -8, -15)} RLC_Type=Parallel Resistance=50ohm
  JJ_Inductance: Lumped RLC Objects=JJ CurrentLine{(0, 0.15, -1.785) -> (0, 0.15, -1.795)} RLC_Type=Parallel Inductance=Lj
mesh:
  JJ_fine_mesh: LengthBased Objects=JJ MaxLength=1um
  saphire_mesh: LengthBased Objects=ChipBase MaxLength=0.9mm
  perfect_e_mesh_tr: LengthBased Objects=[Transmon1, Transmon2] MaxLength=50um
  resonator_mesh: LengthBased Objects=[purcell_resonator, readout_resonator] MaxLength=100um
  initial mesh: MeshMethod=AnsoftClassic
setups:
  Setup1: HfssEigen MinimumFrequency=2GHz NumModes=6 MaxDeltaFreq=0.2 ConvergeOnRealFreq=true MaximumPasses=8 MinimumPasses=2 MinimumConvergedPasses=2 PercentRefinement=30 BasisOrder=-1
source amplitudes:
  #-10:1, #-10:2, #-10:4, #-10:5, #-10:6: 0 0deg
  #-10:3: 1 0deg
field plots:
  Mag_E1: E Field in sapphire_house_back1 on Setup1 : LastAdaptive at Phase=0deg
  Mesh1: MeshPlots over readout_resonator.face(at (0, 0.15, -5.105)) on Setup1 : LastAdaptive at Phase=0deg
  Mesh2: MeshPlots over purcell_resonator.face(at (0, 0.15, -12.485)) on Setup1 : LastAdaptive at Phase=0deg
  Mesh3: MeshPlots over JJ.face on Setup1 : LastAdaptive at Phase=0deg
  Mesh4: MeshPlots over Transmon1.face(at (0, 0.15, -0.71864)) on Setup1 : LastAdaptive at Phase=0deg
  Mesh5: MeshPlots over Transmon2.face(at (0, 0.15, -2.03)) on Setup1 : LastAdaptive at Phase=0deg
  Mesh6: MeshPlots in ChipBase on Setup1 : LastAdaptive at Phase=0deg
reports:
  Freq. vs. pass: re(Mode(1)), re(Mode(2)), re(Mode(3)), re(Mode(4)), re(Mode(5)), re(Mode(6)) vs Pass on Setup1 : AdaptivePass [$ChipBase_end=5.25mm $ChipBase_thickness=0.3mm $ChipBase_width=1.7mm $ChipBase_x=-2.905mm $JJ_length=10um $JJ_width=4um $TransmonAntena_depth=665um $TransmonAntena_length=1.8mm $TransmonAntena_radius=0.25mm $TransmonAntena_width=0.1mm $TransmonLead_length=70um $TransmonLead_width=20um $TransmonPad_length=400um $TransmonPad_width=1000um Lj=9.75nH purcell_fillet=100um purcell_length=5.4mm purcell_readout_gap=2mm purcell_thickness=80um purcell_width=600um readout_fillet=100um readout_length=5.2mm readout_pin_length=6.7mm readout_pin_location=15mm readout_thickness=80um readout_transmon_gap=200um readout_width=600um sapphire_house_length=22mm sapphire_house_pins_diameter=0.5mm sapphire_house_pins_waveguide_diameter=1.15mm sapphire_house_pins_waveguide_length=6mm spacer=0.5mm transmon_pin_length=4mm transmon_pin_location=8.95mm transmon_wg_radius=2mm]

design DoubleCavity (HFSS, Eigenmode, model units mm)
variables:
  transmon_wg_radius = 2mm
  sapphire_house_length = 22mm
  spacer = 0.001mm
  sapphire_house_pins_diameter = 0.5mm
  sapphire_house_pins_waveguide_diameter = 1.15mm
  sapphire_house_pins_waveguide_length = 6mm
  pin_1_length = 5.6mm
  pin_2_length = 6.735mm
  pin_3_length = 0mm
  pin_4_length = 0mm
geometry:
  cavity [vacuum] = polyline(x=0mm, yz in mm: (0, 80.049867) (0, -0.5) (2, -0.5) (2.0021411, -0.46729844) (2.0085551, -0.4347369) (2.0192147, -0.40245484) (2.0340742, -0.37059048) (2.0530699, -0.33928027) (2.0761205, -0.30865828) (2.1031273, -0.27885565) (2.1339746, -0.25) (2.1685304, -0.22221488) (2.2066467, -0.19561929) (2.2481602, -0.17032709) (2.2928932, -0.14644661) (2.3406542, -0.1240801) (2.3912386, -0.10332333) (2.4444298, -0.084265194) (2.5, -0.066987298) (2.5577113, -0.051563629) (2.6173166, -0.038060234) (2.6785605, -0.026534935) (2.741181, -0.017037087) (2.8049097, -0.0096073598) (2.8694738, -0.0042775693) (2.9345969, -0.0010705384) (3, 0) (5.8971211, 0) (8.7942422, 0) (11.691363, 0) (14.588484, 0) (17.485606, 0) (20.382727, 0) (23.279848, 0) (26.176969, 0) (29.07409, 0) (31.971211, 0) (34.868332, 0) (35.215333, 0.015079602) (35.559717, 0.060204709) (35.898889, 0.13503509) (36.23029, 0.23900653) (36.551422, 0.37133512) (36.859864, 0.53102311) (37.153291, 0.7168665) (37.429489, 0.92746407) (37.686377, 1.1612279) (37.922017, 1.4163956) (38.134633, 1.6910431) (38.322621, 1.9830997) (38.484565, 2.2903633) (38.619244, 2.6105172) (38.725641, 2.9411476) (38.802955, 3.2797615) (38.850603, 3.6238058) (38.868225, 3.9706866) (38.855689, 4.3177884) (38.813089, 4.6624941) (38.740746, 5.0022048) (38.639206, 5.334359) (38.509234, 5.6564524) (38.351811, 5.9660565) (38.138418, 6.331881) (37.912365, 6.6956037) (37.673729, 7.057104) (37.422588, 7.4162619) (37.159026, 7.7729582) (36.883129, 8.1270744) (36.59499, 8.478493) (36.294705, 8.8270975) (35.982372, 9.172772) (35.658096, 9.5154018) (35.321984, 9.8548732) (34.974148, 10.191074) (34.614703, 10.523891) (34.243768, 10.853216) (33.861468, 11.178938) (33.467927, 11.50095) (33.063278, 11.819144) (32.647655, 12.133415) (32.221195, 12.443658) (31.78404, 12.749772) (31.336335, 13.051653) (30.878229, 13.349202) (30.409873, 13.642321) (29.931424, 13.930911) (29.44304, 14.214877) (28.944883, 14.494125) (28.437119, 14.768562) (27.919915, 15.038096) (27.393444, 15.30264) (26.857881, 15.562104) (26.313403, 15.816402) (25.760191, 16.065451) (25.198428, 16.309167) (24.628302, 16.54747) (24.05, 16.78028) (23.463716, 17.007521) (22.869644, 17.229116) (22.267981, 17.444993) (21.658926, 17.655079) (21.042683, 17.859305) (20.419454, 18.057603) (19.789448, 18.249907) (19.152874, 18.436154) (18.509942, 18.616281) (17.860866, 18.790229) (17.205862, 18.95794) (16.545147, 19.119359) (15.87894, 19.274431) (15.207463, 19.423106) (15.207457, 19.423108) (15.03344, 19.465775) (14.868499, 19.516664) (14.714185, 19.575297) (14.571946, 19.641123) (14.443117, 19.713524) (14.32891, 19.791819) (14.230395, 19.875274) (14.148499, 19.963106) (14.083991, 20.054488) (14.037476, 20.148563) (14.009391, 20.244447) (14, 20.341241) (14.009391, 20.438035) (14.037476, 20.533919) (14.083991, 20.627994) (14.148499, 20.719376) (14.230395, 20.807208) (14.32891, 20.890663) (14.443117, 20.968958) (14.571946, 21.041359) (14.714185, 21.107185) (14.868499, 21.165818) (15.03344, 21.216707) (15.207457, 21.259374) (15.207463, 21.259376) (17.08309, 21.693964) (18.913841, 22.178435) (20.694905, 22.711517) (22.421603, 23.291809) (24.089399, 23.917785) (25.693912, 24.587803) (27.230927, 25.300102) (28.696407, 26.05281) (30.0865, 26.843951) (31.397556, 27.671446) (32.626131, 28.53312) (33.768996, 29.426711) (34.823151, 30.349871) (35.785824, 31.300175) (36.654488, 32.275126) (37.42686, 33.272164) (38.100911, 34.288668) (38.674872, 35.321969) (39.147233, 36.369353) (39.516753, 37.428066) (39.782464, 38.49533) (39.943665, 39.568338) (39.999934, 40.644274) (39.951123, 41.72031) (39.79736, 42.79362) (39.539049, 43.861383) (39.176868, 44.920796) (38.71177, 45.969075) (38.144976, 47.003465) (37.477974, 48.021251) (36.712518, 49.019757) (35.850617, 49.996362) (34.894537, 50.948498) (33.846788, 51.873666) (32.710124, 52.769435) (31.48753, 53.633451) (30.182218, 54.463444) (28.797617, 55.257235) (27.337364, 56.012738) (25.805296, 56.727969) (24.205438, 57.401047) (22.541991, 58.030206) (20.819327, 58.613792) (19.04197, 59.150273) (17.214589, 59.638239) (15.341986, 60.076407) (13.429079, 60.463628) (11.480894, 60.798884) (9.5025489, 61.081293) (9.5025526, 61.081293) (9.3968602, 61.096423) (9.2929904, 61.114434) (9.1912569, 61.135272) (9.0919671, 61.158874) (8.9954211, 61.185167) (8.9019106, 61.214074) (8.8117181, 61.245506) (8.7251161, 61.279369) (8.6423664, 61.315559) (8.563719, 61.353969) (8.4894116, 61.394481) (8.4196686, 61.436974) (8.3547008, 61.481318) (8.2947045, 61.527381) (8.239861, 61.575022) (8.190336, 61.624098) (8.1462792, 61.674461) (8.1078236, 61.725958) (8.0750856, 61.778434) (8.0481639, 61.831729) (8.0271401, 61.885684) (8.0120775, 61.940136) (8.0030216, 61.994918) (8, 62.049867) (8, 62.799867) (8, 63.549867) (8, 64.299867) (8, 65.049867) (8, 65.799867) (8, 66.549867) (8, 67.299867) (8, 68.049867) (8, 68.799867) (8, 69.549867) (8, 70.299867) (8, 71.049867) (8, 71.799867) (8, 72.549867) (8, 73.299867) (8, 74.049867) (8, 74.799867) (8, 75.549867) (8, 76.299867) (8, 77.049867) (8, 77.799867) (8, 78.549867) (8, 79.299867) (8, 80.049867) (0, 80.049867), covered, Spline from point 2 over 233)
  cavity.sweep_around_axis(axis=Z, angle=360deg)
  saph_house_back_cylin1 = cylinder(axis=Z, base_centre=(0mm, 2.5mm, -sapphire_house_length), radius=3.5mm, height=-spacer)
  saph_house_back_cylin2 = cylinder(axis=Z, base_centre=(0mm, -2.5mm, -sapphire_house_length), radius=3.5mm, height=-spacer)
  sapphire_house_back = box(corner=(-3.5mm, -2.5mm, -sapphire_house_length), size=(7mm, 5mm, -spacer))
  sapphire_house_wg = cylinder(axis=Z, base_centre=(0mm, 0mm, -sapphire_house_length), radius=transmon_wg_radius, height=sapphire_house_length)
  pin_1_wg = cylinder(axis=Y, base_centre=(0mm, 0mm, -8mm), radius=sapphire_house_pins_waveguide_diameter/2, height=transmon_wg_radius + sapphire_house_pins_waveguide_length)
  pin_2_wg = cylinder(axis=Y, base_centre=(0mm, 0mm, -11mm), radius=sapphire_house_pins_waveguide_diameter/2, height=-transmon_wg_radius - sapphire_house_pins_waveguide_length)
  pin_3_wg = cylinder(axis=Y, base_centre=(0mm, 0mm, -15mm), radius=sapphire_house_pins_waveguide_diameter/2, height=transmon_wg_radius + sapphire_house_pins_waveguide_length)
  pin_4_wg = cylinder(axis=Y, base_centre=(0mm, 0mm, -18mm), radius=sapphire_house_pins_waveguide_diameter/2, height=-transmon_wg_radius - sapphire_house_pins_waveguide_length)
  cavity.unite(saph_house_back_cylin1, saph_house_back_cylin2, sapphire_house_back, sapphire_house_wg, pin_1_wg, pin_2_wg, pin_3_wg, pin_4_wg)
mesh:
  cavity_mesh: LengthBased RefineInside Objects=cavity NumMaxElem=1000 MaxLength=1mm
setups:
  Setup1: HfssEigen MinimumFrequency=2GHz NumModes=3 MaxDeltaFreq=0.5 ConvergeOnRealFreq=false MaximumPasses=4 MinimumPasses=2 MinimumConvergedPasses=2 PercentRefinement=30 BasisOrder=-1
source amplitudes:
  #-10:1: 1 0deg
  #-10:2, #-10:3: 0 0deg

design DoubleCavityWithChip (HFSS, Eigenmode, model units mm)
variables:
  transmon_wg_radius = 2mm
  sapphire_house_length = 22mm
  spacer = 0.2mm
  sapphire_house_pins_diameter = 0.5mm
  sapphire_house_pins_waveguide_diameter = 1.15mm
  sapphire_house_pins_waveguide_length = 6mm
  pin_1_length = 5.6mm
  pin_2_length = 0mm
  pin_3_length = 6.735mm
  pin_4_length = 0mm
  Lj = 12nH
  ChipBase_x = -1mm
  ChipBase_y = -0.15mm
  ChipBase_z = -22mm - spacer
  ChipBase_length = 22.8mm
  ChipBase_end = ChipBase_length + ChipBase_z
  ChipBase_thickness = 0.3mm
  ChipBase_width = 2mm
  readout_width = 660um
  readout_start_pos_z = - transmon_end + readout_transmon_gap + readout_thickness / 2
  transmon_end = ChipBase_end - 3.015mm
  readout_length = 5.6mm
  readout_transmon_gap = 150um
  readout_fillet = 100um
  readout_start_pos_x = ChipBase_x + ChipBase_width/2
  readout_start_pos_y = ChipBase_y
  readout_thickness = 130um
  purcell_thickness = 130um
  purcell_readout_gap = 2mm
  purcell_start_pos_z = readout_start_pos_z + readout_length + purcell_readout_gap + readout_thickness / 2 + purcell_thickness / 2
  purcell_start_pos_x = ChipBase_x + ChipBase_width/2
  purcell_width = 660um
  purcell_length = 5.76mm
  purcell_fillet = 100um
  purcell_start_pos_y = ChipBase_y
geometry:
  transmon_pin [perfect conductor] = cylinder(axis=Y, base_centre=(0mm, transmon_wg_radius + sapphire_house_pins_waveguide_length, -8mm), radius=sapphire_house_pins_diameter/2, height=-pin_1_length)
  readout_pin [perfect conductor] = cylinder(axis=Y, base_centre=(0mm, -transmon_wg_radius - sapphire_house_pins_waveguide_length, -11mm), radius=sapphire_house_pins_diameter/2, height=pin_2_length)
  pin_3 [perfect conductor] = cylinder(axis=Y, base_centre=(0mm, transmon_wg_radius + sapphire_house_pins_waveguide_length, -15mm), radius=sapphire_house_pins_diameter/2, height=-pin_3_length)
  pin_4 [perfect conductor] = cylinder(axis=Y, base_centre=(0mm, -transmon_wg_radius - sapphire_house_pins_waveguide_length, -18mm), radius=sapphire_house_pins_diameter/2, height=pin_4_length)
  JJ = rectangle(corner=(ChipBase_x + ChipBase_width/2 - $JJ_width/2, ChipBase_y + ChipBase_thickness, ChipBase_end - $TransmonAntena_depth - $TransmonAntena_length - $TransmonLead_length - $JJ_length), z_size=$JJ_length, x_size=$JJ_width)
  line_jj1 = polyline((ChipBase_x + ChipBase_width/2, -ChipBase_y, ChipBase_end - $TransmonAntena_depth - $TransmonAntena_length - $TransmonLead_length - $JJ_length) (ChipBase_x + ChipBase_width/2, -ChipBase_y, ChipBase_end - $TransmonAntena_depth - $TransmonAntena_length - $TransmonLead_length))
  Transmon1 = rectangle(corner=(ChipBase_x + ChipBase_width/2 - $TransmonPad_width/2, ChipBase_y + ChipBase_thickness, ChipBase_end - $TransmonAntena_depth - $TransmonAntena_length), z_size=$TransmonPad_length, x_size=$TransmonPad_width)
  Rectangle15 = rectangle(corner=(ChipBase_x + ChipBase_width/2 - $TransmonAntena_width/2, ChipBase_y + ChipBase_thickness, ChipBase_end - $TransmonAntena_depth - $TransmonAntena_length), z_size=$TransmonAntena_length, x_size=$TransmonAntena_width)
  Circle2 = circle(normal=Y, centre=(ChipBase_x + ChipBase_width/2, ChipBase_y + ChipBase_thickness, ChipBase_end - $TransmonAntena_depth), radius=$TransmonAntena_radius)
  Rectangle16 = rectangle(corner=(ChipBase_x + ChipBase_width/2 - $TransmonLead_width/2, ChipBase_y + ChipBase_thickness, ChipBase_end - $TransmonAntena_depth - $TransmonAntena_length - $TransmonLead_length), z_size=$TransmonLead_length, x_size=$TransmonLead_width)
  Transmon1.unite(Rectangle15, Circle2, Rectangle16)
  Transmon2 = rectangle(corner=(ChipBase_x + ChipBase_width/2 - $TransmonPad_width/2, ChipBase_y + ChipBase_thickness, ChipBase_end - $TransmonAntena_depth - $TransmonAntena_length - $TransmonPad_length - 2 * $TransmonLead_length - $JJ_length), z_size=$TransmonPad_length, x_size=$TransmonPad_width)
  Rectangle17 = rectangle(corner=(ChipBase_x + ChipBase_width/2 - $TransmonLead_width/2, ChipBase_y + ChipBase_thickness, ChipBase_end - $TransmonAntena_depth - $TransmonAntena_length - $TransmonLead_length - $JJ_length - $TransmonLead_length), z_size=$TransmonLead_length, x_size=$TransmonLead_width)
  Transmon2.unite(Rectangle17)
  ChipBase [sapphire] = box(corner=(ChipBase_x, ChipBase_y, ChipBase_z), size=(ChipBase_width, ChipBase_thickness, ChipBase_length))
  jj_meshbox [vacuum, non-model] = box(corner=(ChipBase_x + ChipBase_width/2 - $JJ_width/2 - 0.05mm, ChipBase_y + ChipBase_thickness - 0.05mm, ChipBase_end - $TransmonAntena_depth - $TransmonAntena_length - $TransmonLead_length - $JJ_length - 0.05mm), size=(0.1mm, 0.1mm, 0.1mm))
  trpad_meshbox [vacuum, non-model] = box(corner=(ChipBase_x + ChipBase_width/2 - $JJ_width/2 - 0.75mm, ChipBase_y + ChipBase_thickness - 0.1mm, ChipBase_end - $TransmonAntena_depth - $TransmonAntena_length - $TransmonLead_length - $JJ_length - 0.75mm), size=(1.5mm, 0.2mm, 1.5mm))
  readout_resonator = polyline((readout_start_pos_z, readout_start_pos_x + 0.5*readout_thickness, readout_start_pos_y) (readout_start_pos_z, readout_start_pos_x - 0.5*readout_thickness, readout_start_pos_y))
  cable_0_path1 = polyline(z=readout_start_pos_y, xy: (readout_start_pos_z, readout_start_pos_x) (-17.6*readout_fillet + readout_length/2 + readout_start_pos_z, readout_start_pos_x) (-17.6*readout_fillet + readout_length/2 + readout_start_pos_z, readout_start_pos_x + readout_width) (-15.4*readout_fillet + readout_length/2 + readout_start_pos_z, readout_start_pos_x + readout_width) (-15.4*readout_fillet + readout_length/2 + readout_start_pos_z, readout_start_pos_x - readout_width) (-13.2*readout_fillet + readout_length/2 + readout_start_pos_z, readout_start_pos_x - readout_width) (-13.2*readout_fillet + readout_length/2 + readout_start_pos_z, readout_start_pos_x + readout_width) (-11.0*readout_fillet + readout_length/2 + readout_start_pos_z, readout_start_pos_x + readout_width) (-11.0*readout_fillet + readout_length/2 + readout_start_pos_z, readout_start_pos_x - readout_width) (-8.8*readout_fillet + readout_length/2 + readout_start_pos_z, readout_start_pos_x - readout_width) (-8.8*readout_fillet + readout_length/2 + readout_start_pos_z, readout_start_pos_x + readout_width) (-6.6*readout_fillet + readout_length/2 + readout_start_pos_z, readout_start_pos_x + readout_width) (-6.6*readout_fillet + readout_length/2 + readout_start_pos_z, readout_start_pos_x - readout_width) (-4.4*readout_fillet + readout_length/2 + readout_start_pos_z, readout_start_pos_x - readout_width) (-4.4*readout_fillet + readout_length/2 + readout_start_pos_z, readout_start_pos_x + readout_width) (-2.2*readout_fillet + readout_length/2 + readout_start_pos_z, readout_start_pos_x + readout_width) (-2.2*readout_fillet + readout_length/2 + readout_start_pos_z, readout_start_pos_x - readout_width) (readout_length/2 + readout_start_pos_z, readout_start_pos_x - readout_width) (readout_length/2 + readout_start_pos_z, readout_start_pos_x + readout_width) (2.2*readout_fillet + readout_length/2 + readout_start_pos_z, readout_start_pos_x + readout_width) (2.2*readout_fillet + readout_length/2 + readout_start_pos_z, readout_start_pos_x - readout_width) (4.4*readout_fillet + readout_length/2 + readout_start_pos_z, readout_start_pos_x - readout_width) (4.4*readout_fillet + readout_length/2 + readout_start_pos_z, readout_start_pos_x + readout_width) (6.6*readout_fillet + readout_length/2 + readout_start_pos_z, readout_start_pos_x + readout_width) (6.6*readout_fillet + readout_length/2 + readout_start_pos_z, readout_start_pos_x - readout_width) (8.8*readout_fillet + readout_length/2 + readout_start_pos_z, readout_start_pos_x - readout_width) (8.8*readout_fillet + readout_length/2 + readout_start_pos_z, readout_start_pos_x + readout_width) (11.0*readout_fillet + readout_length/2 + readout_start_pos_z, readout_start_pos_x + readout_width) (11.0*readout_fillet + readout_length/2 + readout_start_pos_z, readout_start_pos_x - readout_width) (13.2*readout_fillet + readout_length/2 + readout_start_pos_z, readout_start_pos_x - readout_width) (13.2*readout_fillet + readout_length/2 + readout_start_pos_z, readout_start_pos_x + readout_width) (15.4*readout_fillet + readout_length/2 + readout_start_pos_z, readout_start_pos_x + readout_width) (15.4*readout_fillet + readout_length/2 + readout_start_pos_z, readout_start_pos_x - readout_width) (17.6*readout_fillet + readout_length/2 + readout_start_pos_z, readout_start_pos_x - readout_width) (17.6*readout_fillet + readout_length/2 + readout_start_pos_z, readout_start_pos_x) (readout_length + readout_start_pos_z, readout_start_pos_x))
  cable_0_path1.fillet(Vertices=cable_0_path1.vertex(at (4.07, 0, -0.15), at (4.07, 0.66, -0.15), at (4.29, 0.66, -0.15), at (4.29, -0.66, -0.15), at (4.51, -0.66, -0.15), at (4.51, 0.66, -0.15), at (4.73, 0.66, -0.15), at (4.73, -0.66, -0.15), at (4.95, -0.66, -0.15), at (4.95, 0.66, -0.15), at (5.17, 0.66, -0.15), at (5.17, -0.66, -0.15)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) Radius=readout_fillet Setback=0mm)
  readout_resonator.sweep_along_path(cable_0_path1)
  readout_resonator.rotate(axis=X, angle=90deg)
  readout_resonator.rotate(axis=Y, angle=90deg)
  Circle5 = circle(normal=Y, centre=(readout_start_pos_x, -readout_start_pos_y, -readout_start_pos_z), radius=purcell_thickness / 2)
  Circle6 = circle(normal=Y, centre=(readout_start_pos_x, -readout_start_pos_y, -readout_start_pos_z - readout_length), radius=purcell_thickness / 2)
  readout_resonator.unite(Circle5, Circle6)
  purcell_resonator = polyline((purcell_start_pos_z, purcell_start_pos_x + 0.5*purcell_thickness, purcell_start_pos_y) (purcell_start_pos_z, purcell_start_pos_x - 0.5*purcell_thickness, purcell_start_pos_y))
  cable_0_path = polyline(z=purcell_start_pos_y, xy: (purcell_start_pos_z, purcell_start_pos_x) (-17.6*purcell_fillet + purcell_length/2 + purcell_start_pos_z, purcell_start_pos_x) (-17.6*purcell_fillet + purcell_length/2 + purcell_start_pos_z, purcell_start_pos_x + purcell_width) (-15.4*purcell_fillet + purcell_length/2 + purcell_start_pos_z, purcell_start_pos_x + purcell_width) (-15.4*purcell_fillet + purcell_length/2 + purcell_start_pos_z, purcell_start_pos_x - purcell_width) (-13.2*purcell_fillet + purcell_length/2 + purcell_start_pos_z, purcell_start_pos_x - purcell_width) (-13.2*purcell_fillet + purcell_length/2 + purcell_start_pos_z, purcell_start_pos_x + purcell_width) (-11.0*purcell_fillet + purcell_length/2 + purcell_start_pos_z, purcell_start_pos_x + purcell_width) (-11.0*purcell_fillet + purcell_length/2 + purcell_start_pos_z, purcell_start_pos_x - purcell_width) (-8.8*purcell_fillet + purcell_length/2 + purcell_start_pos_z, purcell_start_pos_x - purcell_width) (-8.8*purcell_fillet + purcell_length/2 + purcell_start_pos_z, purcell_start_pos_x + purcell_width) (-6.6*purcell_fillet + purcell_length/2 + purcell_start_pos_z, purcell_start_pos_x + purcell_width) (-6.6*purcell_fillet + purcell_length/2 + purcell_start_pos_z, purcell_start_pos_x - purcell_width) (-4.4*purcell_fillet + purcell_length/2 + purcell_start_pos_z, purcell_start_pos_x - purcell_width) (-4.4*purcell_fillet + purcell_length/2 + purcell_start_pos_z, purcell_start_pos_x + purcell_width) (-2.2*purcell_fillet + purcell_length/2 + purcell_start_pos_z, purcell_start_pos_x + purcell_width) (-2.2*purcell_fillet + purcell_length/2 + purcell_start_pos_z, purcell_start_pos_x - purcell_width) (purcell_length/2 + purcell_start_pos_z, purcell_start_pos_x - purcell_width) (purcell_length/2 + purcell_start_pos_z, purcell_start_pos_x + purcell_width) (2.2*purcell_fillet + purcell_length/2 + purcell_start_pos_z, purcell_start_pos_x + purcell_width) (2.2*purcell_fillet + purcell_length/2 + purcell_start_pos_z, purcell_start_pos_x - purcell_width) (4.4*purcell_fillet + purcell_length/2 + purcell_start_pos_z, purcell_start_pos_x - purcell_width) (4.4*purcell_fillet + purcell_length/2 + purcell_start_pos_z, purcell_start_pos_x + purcell_width) (6.6*purcell_fillet + purcell_length/2 + purcell_start_pos_z, purcell_start_pos_x + purcell_width) (6.6*purcell_fillet + purcell_length/2 + purcell_start_pos_z, purcell_start_pos_x - purcell_width) (8.8*purcell_fillet + purcell_length/2 + purcell_start_pos_z, purcell_start_pos_x - purcell_width) (8.8*purcell_fillet + purcell_length/2 + purcell_start_pos_z, purcell_start_pos_x + purcell_width) (11.0*purcell_fillet + purcell_length/2 + purcell_start_pos_z, purcell_start_pos_x + purcell_width) (11.0*purcell_fillet + purcell_length/2 + purcell_start_pos_z, purcell_start_pos_x - purcell_width) (13.2*purcell_fillet + purcell_length/2 + purcell_start_pos_z, purcell_start_pos_x - purcell_width) (13.2*purcell_fillet + purcell_length/2 + purcell_start_pos_z, purcell_start_pos_x + purcell_width) (15.4*purcell_fillet + purcell_length/2 + purcell_start_pos_z, purcell_start_pos_x + purcell_width) (15.4*purcell_fillet + purcell_length/2 + purcell_start_pos_z, purcell_start_pos_x - purcell_width) (17.6*purcell_fillet + purcell_length/2 + purcell_start_pos_z, purcell_start_pos_x - purcell_width) (17.6*purcell_fillet + purcell_length/2 + purcell_start_pos_z, purcell_start_pos_x) (purcell_length + purcell_start_pos_z, purcell_start_pos_x))
  cable_0_path.fillet(Vertices=cable_0_path.vertex(at (11.8625, 0, -0.15), at (11.8625, 0.66, -0.15), at (12.0825, 0.66, -0.15), at (12.0825, -0.66, -0.15), at (12.3025, -0.66, -0.15), at (12.3025, 0.66, -0.15), at (12.5225, 0.66, -0.15), at (12.5225, -0.66, -0.15), at (12.7425, -0.66, -0.15), at (12.7425, 0.66, -0.15), at (12.9625, 0.66, -0.15), at (12.9625, -0.66, -0.15)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) Radius=purcell_fillet Setback=0mm)
  purcell_resonator.sweep_along_path(cable_0_path)
  purcell_resonator.rotate(axis=X, angle=90deg)
  purcell_resonator.rotate(axis=Y, angle=90deg)
  Circle3 = circle(normal=Y, centre=(purcell_start_pos_x, -purcell_start_pos_y, -purcell_start_pos_z), radius=purcell_thickness / 2)
  Circle4 = circle(normal=Y, centre=(purcell_start_pos_x, -purcell_start_pos_y, -purcell_start_pos_z - purcell_length), radius=purcell_thickness / 2)
  purcell_resonator.unite(Circle3, Circle4)
  resonator_meshbox [vacuum, non-model] = box(corner=(ChipBase_x + ChipBase_width/2 - $JJ_width/2 - 0.75mm, ChipBase_y + ChipBase_thickness - 0.1mm, ChipBase_end - $TransmonAntena_depth - $TransmonAntena_length - $TransmonLead_length - $JJ_length - 0.75mm), size=(1.5mm, 0.2mm, -14mm))
  cavity [vacuum] = polyline(x=0mm, yz in mm: (0, 77.260708) (0, -0.5) (2, -0.5) (2.0021411, -0.46729844) (2.0085551, -0.4347369) (2.0192147, -0.40245484) (2.0340742, -0.37059048) (2.0530699, -0.33928027) (2.0761205, -0.30865828) (2.1031273, -0.27885565) (2.1339746, -0.25) (2.1685304, -0.22221488) (2.2066467, -0.19561929) (2.2481602, -0.17032709) (2.2928932, -0.14644661) (2.3406542, -0.1240801) (2.3912386, -0.10332333) (2.4444298, -0.084265194) (2.5, -0.066987298) (2.5577113, -0.051563629) (2.6173166, -0.038060234) (2.6785605, -0.026534935) (2.741181, -0.017037087) (2.8049097, -0.0096073598) (2.8694738, -0.0042775693) (2.9345969, -0.0010705384) (3, 0) (5.1099794, 0) (7.2199588, 0) (9.3299383, 0) (11.439918, 0) (13.549897, 0) (15.659877, 0) (17.769856, 0) (19.879835, 0) (21.989815, 0) (24.099794, 0) (26.209774, 0) (26.534532, 0.013205338) (26.857147, 0.05273416) (27.175487, 0.11832547) (27.487451, 0.2095462) (27.790979, 0.32579403) (28.084067, 0.46630143) (28.364779, 0.63014067) (28.631262, 0.81622998) (28.881758, 1.0233407) (29.114611, 1.2501052) (29.328284, 1.4950265) (29.521367, 1.7564872) (29.692584, 2.0327611) (29.840806, 2.3220241) (29.965053, 2.6223661) (30.064505, 2.9318042) (30.138506, 3.2482953) (30.186567, 3.5697496) (30.20837, 3.8940447) (30.203772, 4.2190394) (30.172803, 4.5425879) (30.115667, 4.8625538) (30.032742, 5.1768246) (29.924575, 5.4833252) (29.786964, 5.817008) (29.641246, 6.1491075) (29.48746, 6.4795333) (29.325648, 6.8081954) (29.155854, 7.1350044) (28.978124, 7.4598714) (28.792506, 7.782708) (28.599052, 8.1034261) (28.397813, 8.4219387) (28.188845, 8.7381589) (27.972204, 9.0520007) (27.74795, 9.3633786) (27.516143, 9.672208) (27.276846, 9.9784047) (27.030125, 10.281885) (26.776047, 10.582568) (26.514681, 10.880369) (26.246098, 11.17521) (25.970371, 11.467008) (25.687575, 11.755685) (25.397787, 12.041163) (25.101087, 12.323363) (24.797554, 12.602209) (24.487272, 12.877625) (24.170324, 13.149535) (23.846798, 13.417867) (23.516781, 13.682546) (23.180363, 13.943502) (22.837636, 14.200661) (22.488693, 14.453956) (22.133628, 14.703317) (21.772539, 14.948675) (21.405524, 15.189965) (21.032682, 15.42712) (20.654116, 15.660076) (20.269928, 15.88877) (19.880223, 16.113139) (19.485107, 16.333122) (19.084687, 16.548659) (18.679072, 16.759693) (18.268373, 16.966164) (17.852702, 17.168017) (17.432172, 17.365198) (17.006897, 17.557652) (16.576992, 17.745327) (16.142576, 17.928172) (15.703766, 18.106137) (15.260682, 18.279174) (14.813444, 18.447236) (14.813433, 18.447239) (14.693477, 18.495101) (14.581213, 18.54742) (14.477304, 18.60389) (14.38236, 18.664177) (14.296941, 18.727926) (14.22155, 18.794763) (14.15663, 18.864293) (14.102565, 18.936108) (14.059672, 19.009784) (14.028203, 19.084887) (14.008345, 19.160976) (14.000214, 19.237603) (14.003858, 19.314315) (14.019255, 19.390662) (14.046315, 19.466193) (14.084879, 19.540465) (14.134719, 19.61304) (14.195542, 19.68349) (14.26699, 19.751401) (14.348642, 19.816373) (14.440018, 19.878023) (14.540578, 19.935989) (14.649732, 19.989928) (14.766837, 20.039524) (14.766846, 20.039528) (15.993798, 20.546977) (17.184906, 21.094316) (18.337501, 21.680318) (19.449001, 22.303671) (20.516913, 22.962976) (21.538845, 23.656757) (22.512507, 24.383459) (23.435717, 25.141453) (24.306405, 25.92904) (25.12262, 26.744455) (25.882534, 27.585872) (26.584442, 28.451404) (27.226773, 29.339111) (27.808086, 30.247004) (28.327078, 31.173049) (28.782588, 32.115169) (29.173593, 33.071255) (29.499217, 34.039162) (29.758731, 35.016722) (29.951554, 36.001745) (30.077252, 36.992022) (30.135545, 37.985334) (30.126301, 38.979455) (30.049542, 39.972158) (29.905439, 40.961217) (29.694316, 41.944416) (29.416645, 42.919551) (29.073049, 43.884438) (28.664298, 44.836913) (28.191307, 45.774843) (27.655138, 46.696124) (27.056991, 47.598694) (26.398206, 48.480528) (25.680262, 49.33965) (24.904765, 50.174136) (24.073455, 50.982115) (23.188194, 51.761776) (22.250967, 52.511372) (21.263873, 53.229223) (20.229125, 53.91372) (19.149042, 54.56333) (18.026044, 55.176596) (16.862649, 55.752144) (15.661462, 56.288684) (14.425177, 56.785014) (13.156564, 57.240022) (11.858466, 57.652687) (10.533792, 58.022085) (9.1855114, 58.347389) (9.1855104, 58.347389) (9.0988511, 58.367969) (9.0142653, 58.390604) (8.9319477, 58.41524) (8.8520877, 58.441822) (8.7748691, 58.470288) (8.7004695, 58.500573) (8.6290601, 58.532607) (8.5608052, 58.566316) (8.495862, 58.601624) (8.4343797, 58.638447) (8.3765, 58.676703) (8.3223559, 58.716302) (8.2720721, 58.757154) (8.2257643, 58.799165) (8.183539, 58.842238) (8.1454934, 58.886273) (8.111715, 58.931171) (8.0822815, 58.976826) (8.0572608, 59.023135) (8.0367103, 59.06999) (8.0206773, 59.117284) (8.0091987, 59.164908) (8.002301, 59.212753) (8, 59.260708) (8, 60.010708) (8, 60.760708) (8, 61.510708) (8, 62.260708) (8, 63.010708) (8, 63.760708) (8, 64.510708) (8, 65.260708) (8, 66.010708) (8, 66.760708) (8, 67.510708) (8, 68.260708) (8, 69.010708) (8, 69.760708) (8, 70.510708) (8, 71.260708) (8, 72.010708) (8, 72.760708) (8, 73.510708) (8, 74.260708) (8, 75.010708) (8, 75.760708) (8, 76.510708) (8, 77.260708) (0, 77.260708), covered, Spline from point 2 over 233)
  cavity.sweep_around_axis(axis=Z, angle=360deg)
  saph_house_back_cylin1 = cylinder(axis=Z, base_centre=(0mm, 2.5mm, -sapphire_house_length), radius=3.5mm, height=-spacer)
  saph_house_back_cylin2 = cylinder(axis=Z, base_centre=(0mm, -2.5mm, -sapphire_house_length), radius=3.5mm, height=-spacer)
  sapphire_house_back = box(corner=(-3.5mm, -2.5mm, -sapphire_house_length), size=(7mm, 5mm, -spacer))
  sapphire_house_wg = cylinder(axis=Z, base_centre=(0mm, 0mm, -sapphire_house_length), radius=transmon_wg_radius, height=sapphire_house_length)
  pin_1_wg = cylinder(axis=Y, base_centre=(0mm, 0mm, -8mm), radius=sapphire_house_pins_waveguide_diameter/2, height=transmon_wg_radius + sapphire_house_pins_waveguide_length)
  pin_2_wg = cylinder(axis=Y, base_centre=(0mm, 0mm, -11mm), radius=sapphire_house_pins_waveguide_diameter/2, height=-transmon_wg_radius - sapphire_house_pins_waveguide_length)
  pin_3_wg = cylinder(axis=Y, base_centre=(0mm, 0mm, -15mm), radius=sapphire_house_pins_waveguide_diameter/2, height=transmon_wg_radius + sapphire_house_pins_waveguide_length)
  pin_4_wg = cylinder(axis=Y, base_centre=(0mm, 0mm, -18mm), radius=sapphire_house_pins_waveguide_diameter/2, height=-transmon_wg_radius - sapphire_house_pins_waveguide_length)
  cavity.unite(saph_house_back_cylin1, saph_house_back_cylin2, sapphire_house_back, sapphire_house_wg, pin_1_wg, pin_2_wg, pin_3_wg, pin_4_wg)
  Polyline2 = polyline((0mm, 0mm, 0mm) (1mm, 0mm, 1mm))
  group Pins = transmon_pin, readout_pin, pin_3, pin_4
  group TransmonChip = JJ, line_jj1, Transmon1, Transmon2, ChipBase
  group Cavity_1 = cavity
boundaries and excitations:
  JJ_inductance: Lumped RLC Objects=JJ CurrentLine{(0, 0.15, -1.935) -> (0, 0.15, -1.945)} RLC_Type=Parallel Inductance=Lj
  PerfectE: Perfect E Objects=[readout_resonator, purcell_resonator, Transmon2, Transmon1]
  readout_pin_impedance: Lumped RLC Faces=cavity.face(at (0, 8, -15)) CurrentLine{(0, 8, -15.25) -> (0, 8, -15.575)} RLC_Type=Parallel Resistance=50ohm
  transmon_pin_impedance: Lumped RLC Faces=cavity.face(at (0, 8, -8)) CurrentLine{(0mm, 8000mm, -8250mm) -> (0, 8, -8.575)} RLC_Type=Parallel Resistance=50ohm
mesh:
  perfect_e_fine_mesh: LengthBased Objects=[Transmon1, Transmon2, purcell_resonator, readout_resonator] MaxLength=50um
  JJ_fine_mesh: LengthBased Objects=JJ MaxLength=1um
  saphire_mesh: LengthBased Objects=ChipBase MaxLength=1mm
  trpad_meshbox: LengthBased RefineInside Objects=trpad_meshbox MaxLength=50um
  jj_meshbox: LengthBased RefineInside Objects=jj_meshbox MaxLength=50um
  resonator_meshbox: LengthBased RefineInside Objects=resonator_meshbox MaxLength=50um
  cavity_mesh: LengthBased RefineInside Objects=cavity MaxLength=4mm
  initial mesh: MeshMethod=AnsoftClassic
setups:
  Setup1: HfssEigen MinimumFrequency=2GHz NumModes=20 MaxDeltaFreq=0.2 ConvergeOnRealFreq=true MaximumPasses=3 MinimumPasses=2 MinimumConvergedPasses=2 PercentRefinement=30 BasisOrder=-1 DoMaterialLambda=false
source amplitudes:
  #-10:1, #-10:2, #-10:4..#-10:20: 0 0deg
  #-10:3: 1 0deg
output variables:
  uri = Mode(4)
field calculator expressions:
  total_magnetic_field = <Hx,Hy,Hz> | Smooth | MaterialOp(Permeability (mu)) | <Hx,Hy,Hz> | Smooth | Conj | Dot | Real | EnterVolume(AllObjects) | VolumeValue | Integrate
  test = <Hx,Hy,Hz> | Smooth | MaterialOp(Permeability (mu)) | <Hx,Hy,Hz> | Smooth | Conj | Dot | Real | EnterVolume(AllObjects) | VolumeValue | Integrate
  test_e = Fundamental_Quantity(0) | Smooth | Fundamental_Quantity(0) | Smooth | Conj | Dot | Real | EnterVolume(AllObjects) | VolumeValue | Integrate
  Jsurf = test | 1/
  total_magnetic_energy = <Hx,Hy,Hz> | MaterialOp(Permeability (mu)) | <Hx,Hy,Hz> | Conj | Dot | Real | EnterVolume(AllObjects) | VolumeValue | Integrate
  total_electric_energy = Fundamental_Quantity(0) | MaterialOp(Permittivity (epsi)) | Fundamental_Quantity(0) | Conj | Dot | Real | EnterVolume(AllObjects) | VolumeValue | Integrate
  current_line_based_e_real = Fundamental_Quantity(0) | Real | Tangent | Dot | EnterLine(line_jj1) | LineValue | Integrate
  current_line_based_e_imag = Fundamental_Quantity(0) | Imag | Tangent | Dot | EnterLine(line_jj1) | LineValue | Integrate
reports:
  Freq. vs. pass: re(Mode(1)), re(Mode(2)), re(Mode(3)), re(Mode(4)), re(Mode(5)), re(Mode(6)) vs Pass on Setup1 : AdaptivePass [$ChipBase_end=5.25mm $ChipBase_thickness=0.3mm $ChipBase_width=1.7mm $ChipBase_x=-2.905mm $ChipBase_y=19.94mm $ChipBase_z=33.25mm $JJ_length=10um $JJ_width=4um $TransmonAntena_depth=665um $TransmonAntena_length=1.8mm $TransmonAntena_radius=0.25mm $TransmonAntena_width=0.1mm $TransmonLead_length=70um $TransmonLead_width=20um $TransmonPad_length=400um $TransmonPad_width=1000um ChipBase_length=24.8mm ChipBase_thickness=0.3mm ChipBase_width=2mm ChipBase_x=-1mm ChipBase_y=-0.15mm Lj=11nH pin_1_length=5.6mm pin_2_length=0mm pin_3_length=6.735mm pin_4_length=0mm purcell_fillet=100um purcell_length=5.765mm purcell_readout_gap=2mm purcell_thickness=130um purcell_width=660um readout_fillet=100um readout_length=5.6mm readout_thickness=130um readout_transmon_gap=150um readout_width=660um sapphire_house_length=22mm sapphire_house_pins_diameter=0.5mm sapphire_house_pins_waveguide_diameter=1.15mm sapphire_house_pins_waveguide_length=6mm spacer=0.001mm transmon_wg_radius=2mm]

design OnlyChip (HFSS, Eigenmode, model units mm)
variables:
  transmon_wg_radius = 2mm
  sapphire_house_length = 22mm
  spacer = 0.002mm
  sapphire_house_pins_diameter = 0.5mm
  sapphire_house_pins_waveguide_diameter = 1.15mm
  sapphire_house_pins_waveguide_length = 6mm
  pin_1_length = 7mm
  pin_2_length = 0mm
  pin_3_length = 7mm
  pin_4_length = 0mm
  Lj = 11nH
  ChipBase_x = -1mm
  ChipBase_y = -0.15mm
  ChipBase_z = -22mm
  ChipBase_length = 23.6mm
  ChipBase_end = 0.8mm
  ChipBase_thickness = 0.3mm
  ChipBase_width = 2mm
  readout_width = 660um
  readout_start_pos_z = - transmon_end + readout_transmon_gap + readout_thickness / 2
  transmon_end = ChipBase_end - 3.015mm
  readout_length = 5.6mm
  readout_transmon_gap = 150um
  readout_fillet = 100um
  readout_start_pos_x = ChipBase_x + ChipBase_width/2
  readout_start_pos_y = -0.15mm
  readout_thickness = 130um
  purcell_thickness = 130um
  purcell_readout_gap = 2mm
  purcell_start_pos_z = 10.16mm
  purcell_start_pos_x = 0mm
  purcell_width = 660um
  purcell_length = 5.76mm
  purcell_fillet = 100um
  purcell_start_pos_y = -0.15mm
geometry:
  saph_house_back_cylin1 = cylinder(axis=Z, base_centre=(0mm, 2.5mm, -sapphire_house_length), radius=3.5mm, height=-spacer)
  saph_house_back_cylin2 = cylinder(axis=Z, base_centre=(0mm, -2.5mm, -sapphire_house_length), radius=3.5mm, height=-spacer)
  sapphire_house_back = box(corner=(-3.5mm, -2.5mm, -sapphire_house_length), size=(7mm, 5mm, -spacer))
  sapphire_house_wg = cylinder(axis=Z, base_centre=(0mm, 0mm, -sapphire_house_length), radius=transmon_wg_radius, height=sapphire_house_length + 2mm)
  pin_1_wg [vacuum] = cylinder(axis=Y, base_centre=(0mm, 0mm, -8mm), radius=sapphire_house_pins_waveguide_diameter/2, height=transmon_wg_radius + sapphire_house_pins_waveguide_length)
  pin_2_wg = cylinder(axis=Y, base_centre=(0mm, 0mm, -11mm), radius=sapphire_house_pins_waveguide_diameter/2, height=-transmon_wg_radius - sapphire_house_pins_waveguide_length)
  pin_3_wg = cylinder(axis=Y, base_centre=(0mm, 0mm, -15mm), radius=sapphire_house_pins_waveguide_diameter/2, height=transmon_wg_radius + sapphire_house_pins_waveguide_length)
  pin_4_wg = cylinder(axis=Y, base_centre=(0mm, 0mm, -18mm), radius=sapphire_house_pins_waveguide_diameter/2, height=-transmon_wg_radius - sapphire_house_pins_waveguide_length)
  transmon_pin [perfect conductor] = cylinder(axis=Y, base_centre=(0mm, transmon_wg_radius + sapphire_house_pins_waveguide_length, -8mm), radius=sapphire_house_pins_diameter/2, height=-pin_1_length)
  readout_pin [perfect conductor] = cylinder(axis=Y, base_centre=(0mm, -transmon_wg_radius - sapphire_house_pins_waveguide_length, -11mm), radius=sapphire_house_pins_diameter/2, height=pin_2_length)
  pin_3 [perfect conductor] = cylinder(axis=Y, base_centre=(0mm, transmon_wg_radius + sapphire_house_pins_waveguide_length, -15mm), radius=sapphire_house_pins_diameter/2, height=-pin_3_length)
  pin_4 [perfect conductor] = cylinder(axis=Y, base_centre=(0mm, -transmon_wg_radius - sapphire_house_pins_waveguide_length, -18mm), radius=sapphire_house_pins_diameter/2, height=pin_4_length)
  JJ = rectangle(corner=(ChipBase_x + ChipBase_width/2 - $JJ_width/2, ChipBase_y + ChipBase_thickness, ChipBase_end - $TransmonAntena_depth - $TransmonAntena_length - $TransmonLead_length - $JJ_length), z_size=$JJ_length, x_size=$JJ_width)
  line_jj1 = polyline((ChipBase_x + ChipBase_width/2, -ChipBase_y, ChipBase_end - $TransmonAntena_depth - $TransmonAntena_length - $TransmonLead_length - $JJ_length) (ChipBase_x + ChipBase_width/2, -ChipBase_y, ChipBase_end - $TransmonAntena_depth - $TransmonAntena_length - $TransmonLead_length))
  Transmon1 = rectangle(corner=(ChipBase_x + ChipBase_width/2 - $TransmonPad_width/2, ChipBase_y + ChipBase_thickness, ChipBase_end - $TransmonAntena_depth - $TransmonAntena_length), z_size=$TransmonPad_length, x_size=$TransmonPad_width)
  Rectangle15 = rectangle(corner=(ChipBase_x + ChipBase_width/2 - $TransmonAntena_width/2, ChipBase_y + ChipBase_thickness, ChipBase_end - $TransmonAntena_depth - $TransmonAntena_length), z_size=$TransmonAntena_length, x_size=$TransmonAntena_width)
  Circle2 = circle(normal=Y, centre=(ChipBase_x + ChipBase_width/2, ChipBase_y + ChipBase_thickness, ChipBase_end - $TransmonAntena_depth), radius=$TransmonAntena_radius)
  Rectangle16 = rectangle(corner=(ChipBase_x + ChipBase_width/2 - $TransmonLead_width/2, ChipBase_y + ChipBase_thickness, ChipBase_end - $TransmonAntena_depth - $TransmonAntena_length - $TransmonLead_length), z_size=$TransmonLead_length, x_size=$TransmonLead_width)
  Transmon1.unite(Rectangle15, Circle2, Rectangle16)
  Transmon2 = rectangle(corner=(ChipBase_x + ChipBase_width/2 - $TransmonPad_width/2, ChipBase_y + ChipBase_thickness, ChipBase_end - $TransmonAntena_depth - $TransmonAntena_length - $TransmonPad_length - 2 * $TransmonLead_length - $JJ_length), z_size=$TransmonPad_length, x_size=$TransmonPad_width)
  Rectangle17 = rectangle(corner=(ChipBase_x + ChipBase_width/2 - $TransmonLead_width/2, ChipBase_y + ChipBase_thickness, ChipBase_end - $TransmonAntena_depth - $TransmonAntena_length - $TransmonLead_length - $JJ_length - $TransmonLead_length), z_size=$TransmonLead_length, x_size=$TransmonLead_width)
  Transmon2.unite(Rectangle17)
  ChipBase [sapphire] = box(corner=(ChipBase_x, ChipBase_y, ChipBase_z), size=(ChipBase_width, ChipBase_thickness, ChipBase_length))
  jj_meshbox [vacuum, non-model] = box(corner=(ChipBase_x + ChipBase_width/2 - $JJ_width/2 - 0.05mm, ChipBase_y + ChipBase_thickness - 0.05mm, ChipBase_end - $TransmonAntena_depth - $TransmonAntena_length - $TransmonLead_length - $JJ_length - 0.05mm), size=(0.1mm, 0.1mm, 0.1mm))
  trpad_meshbox [vacuum, non-model] = box(corner=(ChipBase_x + ChipBase_width/2 - $JJ_width/2 - 0.75mm, ChipBase_y + ChipBase_thickness - 0.1mm, ChipBase_end - $TransmonAntena_depth - $TransmonAntena_length - $TransmonLead_length - $JJ_length - 0.75mm), size=(1.5mm, 0.3mm, 1.5mm))
  readout_resonator = polyline((readout_start_pos_z, readout_start_pos_x + 0.5*readout_thickness, readout_start_pos_y) (readout_start_pos_z, readout_start_pos_x - 0.5*readout_thickness, readout_start_pos_y))
  cable_0_path1 = polyline(z=readout_start_pos_y, xy: (readout_start_pos_z, readout_start_pos_x) (-17.6*readout_fillet + readout_length/2 + readout_start_pos_z, readout_start_pos_x) (-17.6*readout_fillet + readout_length/2 + readout_start_pos_z, readout_start_pos_x + readout_width) (-15.4*readout_fillet + readout_length/2 + readout_start_pos_z, readout_start_pos_x + readout_width) (-15.4*readout_fillet + readout_length/2 + readout_start_pos_z, readout_start_pos_x - readout_width) (-13.2*readout_fillet + readout_length/2 + readout_start_pos_z, readout_start_pos_x - readout_width) (-13.2*readout_fillet + readout_length/2 + readout_start_pos_z, readout_start_pos_x + readout_width) (-11.0*readout_fillet + readout_length/2 + readout_start_pos_z, readout_start_pos_x + readout_width) (-11.0*readout_fillet + readout_length/2 + readout_start_pos_z, readout_start_pos_x - readout_width) (-8.8*readout_fillet + readout_length/2 + readout_start_pos_z, readout_start_pos_x - readout_width) (-8.8*readout_fillet + readout_length/2 + readout_start_pos_z, readout_start_pos_x + readout_width) (-6.6*readout_fillet + readout_length/2 + readout_start_pos_z, readout_start_pos_x + readout_width) (-6.6*readout_fillet + readout_length/2 + readout_start_pos_z, readout_start_pos_x - readout_width) (-4.4*readout_fillet + readout_length/2 + readout_start_pos_z, readout_start_pos_x - readout_width) (-4.4*readout_fillet + readout_length/2 + readout_start_pos_z, readout_start_pos_x + readout_width) (-2.2*readout_fillet + readout_length/2 + readout_start_pos_z, readout_start_pos_x + readout_width) (-2.2*readout_fillet + readout_length/2 + readout_start_pos_z, readout_start_pos_x - readout_width) (readout_length/2 + readout_start_pos_z, readout_start_pos_x - readout_width) (readout_length/2 + readout_start_pos_z, readout_start_pos_x + readout_width) (2.2*readout_fillet + readout_length/2 + readout_start_pos_z, readout_start_pos_x + readout_width) (2.2*readout_fillet + readout_length/2 + readout_start_pos_z, readout_start_pos_x - readout_width) (4.4*readout_fillet + readout_length/2 + readout_start_pos_z, readout_start_pos_x - readout_width) (4.4*readout_fillet + readout_length/2 + readout_start_pos_z, readout_start_pos_x + readout_width) (6.6*readout_fillet + readout_length/2 + readout_start_pos_z, readout_start_pos_x + readout_width) (6.6*readout_fillet + readout_length/2 + readout_start_pos_z, readout_start_pos_x - readout_width) (8.8*readout_fillet + readout_length/2 + readout_start_pos_z, readout_start_pos_x - readout_width) (8.8*readout_fillet + readout_length/2 + readout_start_pos_z, readout_start_pos_x + readout_width) (11.0*readout_fillet + readout_length/2 + readout_start_pos_z, readout_start_pos_x + readout_width) (11.0*readout_fillet + readout_length/2 + readout_start_pos_z, readout_start_pos_x - readout_width) (13.2*readout_fillet + readout_length/2 + readout_start_pos_z, readout_start_pos_x - readout_width) (13.2*readout_fillet + readout_length/2 + readout_start_pos_z, readout_start_pos_x + readout_width) (15.4*readout_fillet + readout_length/2 + readout_start_pos_z, readout_start_pos_x + readout_width) (15.4*readout_fillet + readout_length/2 + readout_start_pos_z, readout_start_pos_x - readout_width) (17.6*readout_fillet + readout_length/2 + readout_start_pos_z, readout_start_pos_x - readout_width) (17.6*readout_fillet + readout_length/2 + readout_start_pos_z, readout_start_pos_x) (readout_length + readout_start_pos_z, readout_start_pos_x))
  cable_0_path1.fillet(Vertices=cable_0_path1.vertex(at (3.47, 0, -0.15), at (3.47, 0.66, -0.15), at (3.69, 0.66, -0.15), at (3.69, -0.66, -0.15), at (3.91, -0.66, -0.15), at (3.91, 0.66, -0.15), at (4.13, 0.66, -0.15), at (4.13, -0.66, -0.15), at (4.35, -0.66, -0.15), at (4.35, 0.66, -0.15), at (4.57, 0.66, -0.15), at (4.57, -0.66, -0.15)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) Radius=readout_fillet Setback=0mm)
  readout_resonator.sweep_along_path(cable_0_path1)
  readout_resonator.rotate(axis=X, angle=90deg)
  readout_resonator.rotate(axis=Y, angle=90deg)
  Circle5 = circle(normal=Y, centre=(readout_start_pos_x, -readout_start_pos_y, -readout_start_pos_z), radius=purcell_thickness / 2)
  Circle6 = circle(normal=Y, centre=(readout_start_pos_x, -readout_start_pos_y, -readout_start_pos_z - readout_length), radius=purcell_thickness / 2)
  readout_resonator.unite(Circle5, Circle6)
  purcell_resonator = polyline((purcell_start_pos_z, purcell_start_pos_x + 0.5*purcell_thickness, purcell_start_pos_y) (purcell_start_pos_z, purcell_start_pos_x - 0.5*purcell_thickness, purcell_start_pos_y))
  cable_0_path = polyline(z=purcell_start_pos_y, xy: (purcell_start_pos_z, purcell_start_pos_x) (-17.6*purcell_fillet + purcell_length/2 + purcell_start_pos_z, purcell_start_pos_x) (-17.6*purcell_fillet + purcell_length/2 + purcell_start_pos_z, purcell_start_pos_x + purcell_width) (-15.4*purcell_fillet + purcell_length/2 + purcell_start_pos_z, purcell_start_pos_x + purcell_width) (-15.4*purcell_fillet + purcell_length/2 + purcell_start_pos_z, purcell_start_pos_x - purcell_width) (-13.2*purcell_fillet + purcell_length/2 + purcell_start_pos_z, purcell_start_pos_x - purcell_width) (-13.2*purcell_fillet + purcell_length/2 + purcell_start_pos_z, purcell_start_pos_x + purcell_width) (-11.0*purcell_fillet + purcell_length/2 + purcell_start_pos_z, purcell_start_pos_x + purcell_width) (-11.0*purcell_fillet + purcell_length/2 + purcell_start_pos_z, purcell_start_pos_x - purcell_width) (-8.8*purcell_fillet + purcell_length/2 + purcell_start_pos_z, purcell_start_pos_x - purcell_width) (-8.8*purcell_fillet + purcell_length/2 + purcell_start_pos_z, purcell_start_pos_x + purcell_width) (-6.6*purcell_fillet + purcell_length/2 + purcell_start_pos_z, purcell_start_pos_x + purcell_width) (-6.6*purcell_fillet + purcell_length/2 + purcell_start_pos_z, purcell_start_pos_x - purcell_width) (-4.4*purcell_fillet + purcell_length/2 + purcell_start_pos_z, purcell_start_pos_x - purcell_width) (-4.4*purcell_fillet + purcell_length/2 + purcell_start_pos_z, purcell_start_pos_x + purcell_width) (-2.2*purcell_fillet + purcell_length/2 + purcell_start_pos_z, purcell_start_pos_x + purcell_width) (-2.2*purcell_fillet + purcell_length/2 + purcell_start_pos_z, purcell_start_pos_x - purcell_width) (purcell_length/2 + purcell_start_pos_z, purcell_start_pos_x - purcell_width) (purcell_length/2 + purcell_start_pos_z, purcell_start_pos_x + purcell_width) (2.2*purcell_fillet + purcell_length/2 + purcell_start_pos_z, purcell_start_pos_x + purcell_width) (2.2*purcell_fillet + purcell_length/2 + purcell_start_pos_z, purcell_start_pos_x - purcell_width) (4.4*purcell_fillet + purcell_length/2 + purcell_start_pos_z, purcell_start_pos_x - purcell_width) (4.4*purcell_fillet + purcell_length/2 + purcell_start_pos_z, purcell_start_pos_x + purcell_width) (6.6*purcell_fillet + purcell_length/2 + purcell_start_pos_z, purcell_start_pos_x + purcell_width) (6.6*purcell_fillet + purcell_length/2 + purcell_start_pos_z, purcell_start_pos_x - purcell_width) (8.8*purcell_fillet + purcell_length/2 + purcell_start_pos_z, purcell_start_pos_x - purcell_width) (8.8*purcell_fillet + purcell_length/2 + purcell_start_pos_z, purcell_start_pos_x + purcell_width) (11.0*purcell_fillet + purcell_length/2 + purcell_start_pos_z, purcell_start_pos_x + purcell_width) (11.0*purcell_fillet + purcell_length/2 + purcell_start_pos_z, purcell_start_pos_x - purcell_width) (13.2*purcell_fillet + purcell_length/2 + purcell_start_pos_z, purcell_start_pos_x - purcell_width) (13.2*purcell_fillet + purcell_length/2 + purcell_start_pos_z, purcell_start_pos_x + purcell_width) (15.4*purcell_fillet + purcell_length/2 + purcell_start_pos_z, purcell_start_pos_x + purcell_width) (15.4*purcell_fillet + purcell_length/2 + purcell_start_pos_z, purcell_start_pos_x - purcell_width) (17.6*purcell_fillet + purcell_length/2 + purcell_start_pos_z, purcell_start_pos_x - purcell_width) (17.6*purcell_fillet + purcell_length/2 + purcell_start_pos_z, purcell_start_pos_x) (purcell_length + purcell_start_pos_z, purcell_start_pos_x))
  cable_0_path.fillet(Vertices=cable_0_path.vertex(at (11.28, 0, -0.15), at (11.28, 0.66, -0.15), at (11.5, 0.66, -0.15), at (11.5, -0.66, -0.15), at (11.72, -0.66, -0.15), at (11.72, 0.66, -0.15), at (11.94, 0.66, -0.15), at (11.94, -0.66, -0.15), at (12.16, -0.66, -0.15), at (12.16, 0.66, -0.15), at (12.38, 0.66, -0.15), at (12.38, -0.66, -0.15)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) Radius=purcell_fillet Setback=0mm)
  purcell_resonator.sweep_along_path(cable_0_path)
  purcell_resonator.rotate(axis=X, angle=90deg)
  purcell_resonator.rotate(axis=Y, angle=90deg)
  Circle3 = circle(normal=Y, centre=(purcell_start_pos_x, -purcell_start_pos_y, -purcell_start_pos_z), radius=purcell_thickness / 2)
  Circle4 = circle(normal=Y, centre=(purcell_start_pos_x, -purcell_start_pos_y, -purcell_start_pos_z - purcell_length), radius=purcell_thickness / 2)
  purcell_resonator.unite(Circle3, Circle4)
  pin_1_wg.unite(pin_2_wg, pin_3_wg, pin_4_wg, saph_house_back_cylin1, saph_house_back_cylin2, sapphire_house_back, sapphire_house_wg)
  resonator_meshbox [vacuum, non-model] = box(corner=(ChipBase_x + ChipBase_width/2 - $JJ_width/2 - 0.75mm, ChipBase_y + ChipBase_thickness - 0.05mm, ChipBase_end - $TransmonAntena_depth - $TransmonAntena_length - $TransmonLead_length - $JJ_length - 0.75mm), size=(1.5mm, 0.2mm, -14mm))
  group Pins = transmon_pin, readout_pin, pin_3, pin_4
  group TransmonChip = JJ, line_jj1, Transmon1, Transmon2, ChipBase
boundaries and excitations:
  JJ_inductance: Lumped RLC Objects=JJ CurrentLine{(0, 0.15, -1.735) -> (0, 0.15, -1.745)} RLC_Type=Parallel Inductance=Lj
  PerfectE: Perfect E Objects=[readout_resonator, purcell_resonator, Transmon2, Transmon1]
  ROpin_impedance: Lumped RLC Faces=pin_1_wg.face(at (0, 8, -15)) CurrentLine{(0.25, 8, -15) -> (0.575, 8, -15)} RLC_Type=Parallel Resistance=50ohm
mesh:
  perfect_e_fine_mesh: LengthBased Objects=[Transmon1, Transmon2, purcell_resonator, readout_resonator] MaxLength=50um
  JJ_fine_mesh: LengthBased Objects=JJ MaxLength=1um
  saphire_mesh: LengthBased Objects=ChipBase MaxLength=1mm
  trpad_meshbox: LengthBased RefineInside Objects=trpad_meshbox MaxLength=2mm
  jj_meshbox: LengthBased RefineInside Objects=jj_meshbox MaxLength=50um
  resonator_meshbox: LengthBased RefineInside Objects=resonator_meshbox MaxLength=4mm
  initial mesh: MeshMethod=AnsoftClassic
setups:
  Setup1: HfssEigen MinimumFrequency=2GHz NumModes=4 MaxDeltaFreq=0.2 ConvergeOnRealFreq=true MaximumPasses=4 MinimumPasses=3 MinimumConvergedPasses=2 PercentRefinement=30 BasisOrder=-1 DoMaterialLambda=false
source amplitudes:
  #-10:1, #-10:2, #-10:4: 0 0deg
  #-10:3: 1 0deg
field calculator expressions:
  total_magnetic_energy = <Hx,Hy,Hz> | MaterialOp(Permeability (mu)) | <Hx,Hy,Hz> | Conj | Dot | Real | EnterVolume(AllObjects) | VolumeValue | Integrate
  uri = Fundamental_Quantity(0) | MaterialOp(Permittivity (epsi)) | Fundamental_Quantity(0) | Conj | Dot | Real | EnterVolume(AllObjects) | VolumeValue | Integrate
  current_line_based_e_real = Fundamental_Quantity(0) | Real | Tangent | Dot | EnterLine(line_jj1) | LineValue | Integrate
  current_line_based_e_imag = Fundamental_Quantity(0) | Imag | Tangent | Dot | EnterLine(line_jj1) | LineValue | Integrate
  total_electric_energy = Fundamental_Quantity(0) | MaterialOp(Permittivity (epsi)) | Fundamental_Quantity(0) | Conj | Dot | Real | EnterVolume(AllObjects) | VolumeValue | Integrate
field plots:
  JJ: MeshPlots over JJ.face on Setup1 : LastAdaptive at Phase=0deg
  TopTrPad: MeshPlots over Transmon1.face(at (0, 0.15, -0.66864)) on Setup1 : LastAdaptive at Phase=0deg
  BotTrPad: MeshPlots over Transmon2.face(at (0, 0.15, -1.98)) on Setup1 : LastAdaptive at Phase=0deg
  jj_meshbox: MeshPlots in jj_meshbox on Setup1 : LastAdaptive at Phase=0deg
  tr_meshbox: MeshPlots in trpad_meshbox on Setup1 : LastAdaptive at Phase=0deg
  Mag_E1: E Field in pin_1_wg on Setup1 : LastAdaptive at Phase=0deg
  Mag_E2: E Field in ChipBase on Setup1 : LastAdaptive at Phase=0deg
reports:
  Freq. vs. pass: re(Mode(1)), re(Mode(2)), re(Mode(3)), re(Mode(4)) vs Pass on Setup1 : AdaptivePass [$ChipBase_end=5.25mm $ChipBase_thickness=0.3mm $ChipBase_width=1.7mm $ChipBase_x=-2.905mm $ChipBase_y=19.94mm $ChipBase_z=33.25mm $JJ_length=10um $JJ_width=4um $TransmonAntena_depth=665um $TransmonAntena_length=1.8mm $TransmonAntena_radius=0.25mm $TransmonAntena_width=0.1mm $TransmonLead_length=70um $TransmonLead_width=20um $TransmonPad_length=400um $TransmonPad_width=1000um ChipBase_end=0.8mm ChipBase_length=23.6mm ChipBase_thickness=0.3mm ChipBase_width=2mm ChipBase_x=-1mm ChipBase_y=-0.15mm ChipBase_z=-22mm Lj=11nH pin_1_length=7mm pin_2_length=0mm pin_3_length=7mm pin_4_length=0mm purcell_fillet=100um purcell_length=5.76mm purcell_readout_gap=2mm purcell_start_pos_x=0mm purcell_start_pos_y=-0.15mm purcell_start_pos_z=10.16mm purcell_thickness=130um purcell_width=660um readout_fillet=100um readout_length=5.6mm readout_start_pos_y=-0.15mm readout_thickness=130um readout_transmon_gap=150um readout_width=660um sapphire_house_length=22mm sapphire_house_pins_diameter=0.5mm sapphire_house_pins_waveguide_diameter=1.15mm sapphire_house_pins_waveguide_length=6mm spacer=0.001mm transmon_wg_radius=2mm]

design OnlyCavity (HFSS, HFSS Terminal Network, model units mm)
variables:
  transmon_wg_radius = 2mm
  sapphire_house_length = 22mm
  spacer = 1mm
  sapphire_house_pins_waveguide_diameter = 1.15mm
  sapphire_house_pins_waveguide_length = 6mm
geometry:
  cavity [vacuum] = polyline(x=0mm, yz in mm: (0, 77.260708) (0, -0.5) (2, -0.5) (2.0021411, -0.46729844) (2.0085551, -0.4347369) (2.0192147, -0.40245484) (2.0340742, -0.37059048) (2.0530699, -0.33928027) (2.0761205, -0.30865828) (2.1031273, -0.27885565) (2.1339746, -0.25) (2.1685304, -0.22221488) (2.2066467, -0.19561929) (2.2481602, -0.17032709) (2.2928932, -0.14644661) (2.3406542, -0.1240801) (2.3912386, -0.10332333) (2.4444298, -0.084265194) (2.5, -0.066987298) (2.5577113, -0.051563629) (2.6173166, -0.038060234) (2.6785605, -0.026534935) (2.741181, -0.017037087) (2.8049097, -0.0096073598) (2.8694738, -0.0042775693) (2.9345969, -0.0010705384) (3, 0) (5.1099794, 0) (7.2199588, 0) (9.3299383, 0) (11.439918, 0) (13.549897, 0) (15.659877, 0) (17.769856, 0) (19.879835, 0) (21.989815, 0) (24.099794, 0) (26.209774, 0) (26.534532, 0.013205338) (26.857147, 0.05273416) (27.175487, 0.11832547) (27.487451, 0.2095462) (27.790979, 0.32579403) (28.084067, 0.46630143) (28.364779, 0.63014067) (28.631262, 0.81622998) (28.881758, 1.0233407) (29.114611, 1.2501052) (29.328284, 1.4950265) (29.521367, 1.7564872) (29.692584, 2.0327611) (29.840806, 2.3220241) (29.965053, 2.6223661) (30.064505, 2.9318042) (30.138506, 3.2482953) (30.186567, 3.5697496) (30.20837, 3.8940447) (30.203772, 4.2190394) (30.172803, 4.5425879) (30.115667, 4.8625538) (30.032742, 5.1768246) (29.924575, 5.4833252) (29.786964, 5.817008) (29.641246, 6.1491075) (29.48746, 6.4795333) (29.325648, 6.8081954) (29.155854, 7.1350044) (28.978124, 7.4598714) (28.792506, 7.782708) (28.599052, 8.1034261) (28.397813, 8.4219387) (28.188845, 8.7381589) (27.972204, 9.0520007) (27.74795, 9.3633786) (27.516143, 9.672208) (27.276846, 9.9784047) (27.030125, 10.281885) (26.776047, 10.582568) (26.514681, 10.880369) (26.246098, 11.17521) (25.970371, 11.467008) (25.687575, 11.755685) (25.397787, 12.041163) (25.101087, 12.323363) (24.797554, 12.602209) (24.487272, 12.877625) (24.170324, 13.149535) (23.846798, 13.417867) (23.516781, 13.682546) (23.180363, 13.943502) (22.837636, 14.200661) (22.488693, 14.453956) (22.133628, 14.703317) (21.772539, 14.948675) (21.405524, 15.189965) (21.032682, 15.42712) (20.654116, 15.660076) (20.269928, 15.88877) (19.880223, 16.113139) (19.485107, 16.333122) (19.084687, 16.548659) (18.679072, 16.759693) (18.268373, 16.966164) (17.852702, 17.168017) (17.432172, 17.365198) (17.006897, 17.557652) (16.576992, 17.745327) (16.142576, 17.928172) (15.703766, 18.106137) (15.260682, 18.279174) (14.813444, 18.447236) (14.813433, 18.447239) (14.693477, 18.495101) (14.581213, 18.54742) (14.477304, 18.60389) (14.38236, 18.664177) (14.296941, 18.727926) (14.22155, 18.794763) (14.15663, 18.864293) (14.102565, 18.936108) (14.059672, 19.009784) (14.028203, 19.084887) (14.008345, 19.160976) (14.000214, 19.237603) (14.003858, 19.314315) (14.019255, 19.390662) (14.046315, 19.466193) (14.084879, 19.540465) (14.134719, 19.61304) (14.195542, 19.68349) (14.26699, 19.751401) (14.348642, 19.816373) (14.440018, 19.878023) (14.540578, 19.935989) (14.649732, 19.989928) (14.766837, 20.039524) (14.766846, 20.039528) (15.993798, 20.546977) (17.184906, 21.094316) (18.337501, 21.680318) (19.449001, 22.303671) (20.516913, 22.962976) (21.538845, 23.656757) (22.512507, 24.383459) (23.435717, 25.141453) (24.306405, 25.92904) (25.12262, 26.744455) (25.882534, 27.585872) (26.584442, 28.451404) (27.226773, 29.339111) (27.808086, 30.247004) (28.327078, 31.173049) (28.782588, 32.115169) (29.173593, 33.071255) (29.499217, 34.039162) (29.758731, 35.016722) (29.951554, 36.001745) (30.077252, 36.992022) (30.135545, 37.985334) (30.126301, 38.979455) (30.049542, 39.972158) (29.905439, 40.961217) (29.694316, 41.944416) (29.416645, 42.919551) (29.073049, 43.884438) (28.664298, 44.836913) (28.191307, 45.774843) (27.655138, 46.696124) (27.056991, 47.598694) (26.398206, 48.480528) (25.680262, 49.33965) (24.904765, 50.174136) (24.073455, 50.982115) (23.188194, 51.761776) (22.250967, 52.511372) (21.263873, 53.229223) (20.229125, 53.91372) (19.149042, 54.56333) (18.026044, 55.176596) (16.862649, 55.752144) (15.661462, 56.288684) (14.425177, 56.785014) (13.156564, 57.240022) (11.858466, 57.652687) (10.533792, 58.022085) (9.1855114, 58.347389) (9.1855104, 58.347389) (9.0988511, 58.367969) (9.0142653, 58.390604) (8.9319477, 58.41524) (8.8520877, 58.441822) (8.7748691, 58.470288) (8.7004695, 58.500573) (8.6290601, 58.532607) (8.5608052, 58.566316) (8.495862, 58.601624) (8.4343797, 58.638447) (8.3765, 58.676703) (8.3223559, 58.716302) (8.2720721, 58.757154) (8.2257643, 58.799165) (8.183539, 58.842238) (8.1454934, 58.886273) (8.111715, 58.931171) (8.0822815, 58.976826) (8.0572608, 59.023135) (8.0367103, 59.06999) (8.0206773, 59.117284) (8.0091987, 59.164908) (8.002301, 59.212753) (8, 59.260708) (8, 60.010708) (8, 60.760708) (8, 61.510708) (8, 62.260708) (8, 63.010708) (8, 63.760708) (8, 64.510708) (8, 65.260708) (8, 66.010708) (8, 66.760708) (8, 67.510708) (8, 68.260708) (8, 69.010708) (8, 69.760708) (8, 70.510708) (8, 71.260708) (8, 72.010708) (8, 72.760708) (8, 73.510708) (8, 74.260708) (8, 75.010708) (8, 75.760708) (8, 76.510708) (8, 77.260708) (0, 77.260708), covered, Spline from point 2 over 233)
  cavity.sweep_around_axis(axis=Z, angle=360deg)
  saph_house_back_cylin1 = cylinder(axis=Z, base_centre=(0mm, 2.5mm, -sapphire_house_length), radius=3.5mm, height=-spacer)
  saph_house_back_cylin2 = cylinder(axis=Z, base_centre=(0mm, -2.5mm, -sapphire_house_length), radius=3.5mm, height=-spacer)
  sapphire_house_back = box(corner=(-3.5mm, -2.5mm, -sapphire_house_length), size=(7mm, 5mm, -spacer))
  sapphire_house_wg = cylinder(axis=Z, base_centre=(0mm, 0mm, -sapphire_house_length), radius=transmon_wg_radius, height=sapphire_house_length)
  pin_1_wg = cylinder(axis=Y, base_centre=(0mm, 0mm, -8mm), radius=sapphire_house_pins_waveguide_diameter/2, height=transmon_wg_radius + sapphire_house_pins_waveguide_length)
  pin_2_wg = cylinder(axis=Y, base_centre=(0mm, 0mm, -11mm), radius=sapphire_house_pins_waveguide_diameter/2, height=-transmon_wg_radius - sapphire_house_pins_waveguide_length)
  pin_3_wg = cylinder(axis=Y, base_centre=(0mm, 0mm, -15mm), radius=sapphire_house_pins_waveguide_diameter/2, height=transmon_wg_radius + sapphire_house_pins_waveguide_length)
  pin_4_wg = cylinder(axis=Y, base_centre=(0mm, 0mm, -18mm), radius=sapphire_house_pins_waveguide_diameter/2, height=-transmon_wg_radius - sapphire_house_pins_waveguide_length)
  cavity.unite(saph_house_back_cylin1, saph_house_back_cylin2, sapphire_house_back, sapphire_house_wg, pin_1_wg, pin_2_wg, pin_3_wg, pin_4_wg)
mesh:
  cavity_mesh: LengthBased RefineInside Objects=cavity NumMaxElem=1000 MaxLength=1mm
